* NGSPICE file created from dd2_g4__n4_8eff_1.ext - technology: sky130A

.subckt dd2_g4__n4_8eff_1 A B C D VGND VNB VPB VPWR Y
X0 VPWR.t2 C.t1 a_519_297.t3 VPB.t5 sky130_fd_pr__pfet_01v8_hvt ad=0.175 pd=1.35 as=0.175 ps=1.35 w=1 l=0.15 sa=3.18 sb=0.76
X1 a_419_47.t0 a_237_47.t3 VGND.t3 VNB.t1 sky130_fd_pr__nfet_01v8 ad=0.11375 pd=1 as=0.11375 ps=1 w=0.65 l=0.15 sa=0.76 sb=0.76
X2 a_625_47.t0 a_237_47.t2 VGND.t2 VNB.t0 sky130_fd_pr__nfet_01v8 ad=0.11375 pd=1 as=0.10725 ps=0.98 w=0.65 l=0.15 sa=0.74 sb=1.26
X3 a_519_297.t1 a_465_199# a_419_297.t1 VPB.t2 sky130_fd_pr__pfet_01v8_hvt ad=0.395 pd=1.79 as=0.175 ps=1.35 w=1 l=0.15 sa=1.26 sb=2.68
X4 VGND.t4 a_465_199# a_625_47.t1 VNB.t3 sky130_fd_pr__nfet_01v8 ad=0.10725 pd=0.98 as=0.169 ps=1.82 w=0.65 l=0.15 sa=0.26 sb=1.74
X5 VGND.t0 A.t0 a_237_47.t1 VNB.t7 sky130_fd_pr__nfet_01v8 ad=0.11375 pd=1 as=0.169 ps=1.82 w=0.65 l=0.15 sa=0.26 sb=1.26
X6 a_419_297.t0 a_237_47.t5 VPWR.t3 VPB.t1 sky130_fd_pr__pfet_01v8_hvt ad=0.175 pd=1.35 as=0.175 ps=1.35 w=1 l=0.15 sa=0.76 sb=3.18
X7 Y.t3 a_465_199# a_519_297.t2 VPB.t3 sky130_fd_pr__pfet_01v8_hvt ad=0.165 pd=1.33 as=0.395 ps=1.79 w=1 l=0.15 sa=2.2 sb=1.74
X8 a_519_297.t0 a_237_47.t4 Y.t2 VPB.t0 sky130_fd_pr__pfet_01v8_hvt ad=0.175 pd=1.35 as=0.165 ps=1.33 w=1 l=0.15 sa=2.68 sb=1.26
X9 a_131_47# B.t0 VGND.t1 VNB.t4 sky130_fd_pr__nfet_01v8 ad=0.169 pd=1.82 as=0.169 ps=1.82 w=0.65 l=0.15 sa=0.26 sb=0.26
X10 Y.t1 D.t0 a_519_47.t2 VNB.t6 sky130_fd_pr__nfet_01v8 ad=0.169 pd=1.82 as=0.11375 ps=1 w=0.65 l=0.15 sa=1.74 sb=0.26
X11 a_131_297# B.t1 VPWR.t4 VPB.t4 sky130_fd_pr__pfet_01v8_hvt ad=0.26 pd=2.52 as=0.26 ps=2.52 w=1 l=0.15 sa=0.26 sb=0.26
X12 VPWR.t1 A.t1 a_237_47.t0 VPB.t7 sky130_fd_pr__pfet_01v8_hvt ad=0.175 pd=1.35 as=0.26 ps=2.52 w=1 l=0.15 sa=0.26 sb=3.68
X13 Y.t0 D.t1 VPWR.t0 VPB.t6 sky130_fd_pr__pfet_01v8_hvt ad=0.26 pd=2.52 as=0.175 ps=1.35 w=1 l=0.15 sa=3.68 sb=0.26
X14 a_519_47.t0 a_465_199# a_419_47.t1 VNB.t2 sky130_fd_pr__nfet_01v8 ad=0.169 pd=1.82 as=0.11375 ps=1 w=0.65 l=0.15 sa=1.26 sb=0.26
X15 a_519_47.t1 C.t0 a_625_47.t2 VNB.t5 sky130_fd_pr__nfet_01v8 ad=0.11375 pd=1 as=0.11375 ps=1 w=0.65 l=0.15 sa=1.24 sb=0.76
R0 VGND.n1 VGND.n0 9.3005
R1 VGND.n3 VGND.n2 9.3005
R2 VGND.n5 VGND.n4 9.3005
R3 VGND VGND.n11 0.0226354
R4 VGND.n11 VGND.n1 0.120292
R5 VGND.n1 VGND.n3 0.120292
R6 VGND.n3 VGND.n5 0.120292
R7 VGND.n5 VGND.n6 0.171734
R8 VGND.n6 VGND.n7 219.958
R9 VGND.n11 VGND.n10 19.8417
R10 VGND.n10 VGND.n0 24.0946
R11 VGND.n0 VGND.n2 34.6358
R12 VGND.n2 VGND.n4 34.6358
R13 VGND.n4 VGND.n9 12.0476
R14 VGND.n9 VGND.n6 30.1648
R15 VGND.n10 VGND.t1 160.222
R16 VGND.n9 VGND.n8 207.213
R17 VGND.n8 VGND.t0 32.3082
R18 VGND.n8 VGND.t3 32.3082
R19 VGND.n7 VGND.t4 30.462
R20 VGND.n7 VGND.t2 30.462
R21 Y Y.n4 6.8005
R22 Y Y.n4 3.2005
R23 Y.n4 Y.n0 0.2005
R24 Y.n1 Y.n3 31.3486
R25 Y.n0 Y.n1 68.3417
R26 Y.n3 Y.n2 585
R27 Y Y.n3 6.4005
R28 Y.n2 Y.t3 32.5055
R29 Y.n2 Y.t2 32.5055
R30 Y.n1 Y.t0 227.356
R31 Y.n0 Y.t1 268.077
R32 VPWR.n2 VPWR.n1 9.3005
R33 VPWR.n4 VPWR.n3 9.3005
R34 VPWR.n6 VPWR.n5 9.3005
R35 VPWR VPWR.n0 0.0226354
R36 VPWR.n0 VPWR.n2 0.120292
R37 VPWR.n2 VPWR.n4 0.120292
R38 VPWR.n4 VPWR.n6 0.120292
R39 VPWR.n6 VPWR.n7 0.147804
R40 VPWR.n7 VPWR.n11 243.056
R41 VPWR.n0 VPWR.n8 19.8417
R42 VPWR.n8 VPWR.n1 24.0946
R43 VPWR.n1 VPWR.n3 34.6358
R44 VPWR.n3 VPWR.n5 34.6358
R45 VPWR.n5 VPWR.n10 12.0476
R46 VPWR.n10 VPWR.n7 30.1887
R47 VPWR.n11 VPWR.t2 34.4755
R48 VPWR.n11 VPWR.t0 34.4755
R49 VPWR.n10 VPWR.n9 607.212
R50 VPWR.n9 VPWR.t1 34.4755
R51 VPWR.n9 VPWR.t3 34.4755
R52 VPWR.n8 VPWR.t4 257.474
R53 D D.n0 158.4
R54 D.n0 D.t0 169.237
R55 D.n0 D.t1 241.536
R56 C C.n0 158.4
R57 C.n0 C.t0 169.237
R58 C.n0 C.t1 241.536
R59 A A.n0 158.4
R60 A.n0 A.t0 169.237
R61 A.n0 A.t1 241.536
R62 B B.n0 158.4
R63 B.n0 B.t0 169.237
R64 B.n0 B.t1 241.536
R65 VPB VPB.t4 257.478
R66 VPB.t4 VPB.t7 556.386
R67 VPB.t7 VPB.t1 295.95
R68 VPB.t1 VPB.t2 295.95
R69 VPB.t2 VPB.t3 556.386
R70 VPB.t3 VPB.t0 284.113
R71 VPB.t0 VPB.t5 295.95
R72 VPB.t5 VPB.t6 295.95
R73 VNB VNB.t4 1238.83
R74 VNB.t4 VNB.t7 2677.02
R75 VNB.t7 VNB.t1 1423.95
R76 VNB.t1 VNB.t2 1423.95
R77 VNB.t2 VNB.t3 2677.02
R78 VNB.t3 VNB.t0 1366.99
R79 VNB.t0 VNB.t5 1423.95
R80 VNB.t5 VNB.t6 1423.95
R81 a_625_47.n0 a_625_47.t1 291.462
R82 a_625_47.t0 a_625_47.n0 32.3082
R83 a_625_47.n0 a_625_47.t2 32.3082
R84 a_519_47.t0 a_519_47.n0 250.285
R85 a_519_47.n0 a_519_47.t1 32.3082
R86 a_519_47.n0 a_519_47.t2 32.3082
R87 a_419_47.t0 a_419_47.t1 64.6159
R88 a_519_297.n0 a_519_297.n1 573.062
R89 a_519_297.t0 a_519_297.n0 34.4755
R90 a_519_297.n0 a_519_297.t3 34.4755
R91 a_519_297.n1 a_519_297.t1 77.8155
R92 a_519_297.n1 a_519_297.t2 77.8155
R93 a_419_297.t0 a_419_297.t1 68.9505
R94 a_237_47.t0 a_237_47.n1 287.411
R95 a_237_47.n1 a_237_47.n0 152
R96 a_237_47.n1 a_237_47.t1 190.625
R97 a_237_47.n1 a_237_47.n2 177.581
R98 a_237_47.n2 a_237_47.t2 169.237
R99 a_237_47.n2 a_237_47.t4 241.536
R100 a_237_47.n0 a_237_47.t3 169.237
R101 a_237_47.n0 a_237_47.t5 241.536
C0 C VGND 0.01265f
C1 VPB VPWR 0.17564f
C2 B A 0.01232f
C3 VPWR Y 0.13351f
C4 VPB a_131_47# 0.00108f
C5 VPB a_131_297# 0.00682f
C6 a_131_297# Y 0
C7 A VGND 0.0158f
C8 VPB C 0.031f
C9 C Y 0.01285f
C10 a_131_47# VPWR 0
C11 VPWR a_131_297# 0.06539f
C12 a_131_47# a_131_297# 0.00453f
C13 D VGND 0.01567f
C14 VPWR C 0.02428f
C15 VPB A 0.03282f
C16 A Y 0
C17 B VGND 0.02816f
C18 a_465_199# VGND 0.03099f
C19 VPWR A 0.01611f
C20 VPB D 0.03474f
C21 D Y 0.03978f
C22 B VPB 0.03871f
C23 B Y 0
C24 VPB a_465_199# 0.09704f
C25 Y a_465_199# 0.00388f
C26 VPWR D 0.02487f
C27 VPB VGND 0.01489f
C28 Y VGND 0.02415f
C29 B VPWR 0.02945f
C30 VPWR a_465_199# 0.03107f
C31 B a_131_47# 0.00801f
C32 B a_131_297# 0.01123f
C33 C D 0.03085f
C34 VPWR VGND 0.03014f
C35 a_131_47# VGND 0.04749f
C36 a_131_297# VGND 0.00182f
C37 VPB Y 0.02638f
C38 VGND VNB 0.0593f
C39 Y VNB 0f
C40 VPWR VNB 0f
C41 D VNB 0.0519f
C42 C VNB 0.02046f
C43 A VNB 0.03152f
C44 B VNB 0.07519f
C45 VPB VNB 0.68424f
C46 a_131_47# VNB 0.0214f
C47 a_131_297# VNB 0.02315f
C48 a_237_47.t0 VNB 0.13127f
C49 a_237_47.n0 VNB 0.04923f
C50 a_237_47.n1 VNB 0.37313f
C51 a_237_47.n2 VNB 0.05996f
C52 a_237_47.t1 VNB 0.08856f
C53 a_419_297.t0 VNB 0.04383f
C54 a_419_297.t1 VNB 0.10742f
C55 a_519_297.t0 VNB 0.04107f
C56 a_519_297.n0 VNB 0.07382f
C57 a_519_297.n1 VNB 0.1382f
C58 a_519_297.t1 VNB 0.12537f
C59 a_519_297.t2 VNB 0.03719f
C60 a_519_297.t3 VNB 0.04606f
C61 a_419_47.t0 VNB 0.03227f
C62 a_419_47.t1 VNB 0.0145f
C63 a_519_47.t0 VNB 0.1706f
C64 a_519_47.n0 VNB 0.20934f
C65 a_519_47.t1 VNB 0.04103f
C66 a_519_47.t2 VNB 0.03834f
C67 a_625_47.t0 VNB 0.03596f
C68 a_625_47.n0 VNB 0.12532f
C69 a_625_47.t1 VNB 0.11235f
C70 a_625_47.t2 VNB 0.03957f
C71 VPB.t0 VNB 0.0462f
C72 VPB.t1 VNB 0.04714f
C73 VPB.t2 VNB 0.06789f
C74 VPB.t3 VNB 0.06694f
C75 VPB.t4 VNB 0.06482f
C76 VPB.t5 VNB 0.04714f
C77 VPB.t6 VNB 0.09617f
C78 VPB.t7 VNB 0.06789f
C79 B.n0 VNB 0.04245f
C80 A.n0 VNB 0.05603f
C81 C.n0 VNB 0.05979f
C82 D.n0 VNB 0.05227f
C83 VPWR.n0 VNB 0.025f
C84 VPWR.n1 VNB 0.0105f
C85 VPWR.n2 VNB 0.03495f
C86 VPWR.n3 VNB 0.01238f
C87 VPWR.n4 VNB 0.03495f
C88 VPWR.n5 VNB 0.00834f
C89 VPWR.n6 VNB 0.04405f
C90 VPWR.n7 VNB 0.38809f
C91 VPWR.t4 VNB 0.06277f
C92 VPWR.n8 VNB 0.04005f
C93 VPWR.t1 VNB 0.04158f
C94 VPWR.t3 VNB 0.03844f
C95 VPWR.n9 VNB 0.02801f
C96 VPWR.n10 VNB 0.02152f
C97 VPWR.n11 VNB 0.03444f
C98 VPWR.t2 VNB 0.04344f
C99 VPWR.t0 VNB 0.03972f
C100 Y.t1 VNB 0.05372f
C101 Y.n0 VNB 0.03159f
C102 Y.t0 VNB 0.08287f
C103 Y.n1 VNB 0.12624f
C104 Y.t3 VNB 0.01925f
C105 Y.t2 VNB 0.04384f
C106 Y.n2 VNB 0.03851f
C107 Y.n3 VNB 0.05064f
C108 Y.n4 VNB 0.00793f
C109 VGND.n0 VNB 0.0084f
C110 VGND.n1 VNB 0.02797f
C111 VGND.n2 VNB 0.00991f
C112 VGND.n3 VNB 0.02797f
C113 VGND.n4 VNB 0.00668f
C114 VGND.n5 VNB 0.07071f
C115 VGND.n6 VNB 0.26367f
C116 VGND.t4 VNB 0.00679f
C117 VGND.t2 VNB 0.02457f
C118 VGND.n7 VNB 0.01583f
C119 VGND.t0 VNB 0.02725f
C120 VGND.t3 VNB 0.02498f
C121 VGND.n8 VNB 0.01513f
C122 VGND.n9 VNB 0.01671f
C123 VGND.t1 VNB 0.03523f
C124 VGND.n10 VNB 0.02658f
C125 VGND.n11 VNB 0.02f
.ends
