.subckt dd2_g4__n4_2bff_1 A B C D VGND VNB VPB VPWR Y
X0 _s1 A VGND VNB sky130_fd_pr__nfet_01v8 w=650000u l=150000u
X1 Y D n1 VNB sky130_fd_pr__nfet_01v8 w=650000u l=150000u
X2 n1 _s1 n2 VNB sky130_fd_pr__nfet_01v8 w=650000u l=150000u
X3 n2 B VGND VNB sky130_fd_pr__nfet_01v8 w=650000u l=150000u
X4 n1 C n3 VNB sky130_fd_pr__nfet_01v8 w=650000u l=150000u
X5 n3 _s1 VGND VNB sky130_fd_pr__nfet_01v8 w=650000u l=150000u
X6 n3 B VGND VNB sky130_fd_pr__nfet_01v8 w=650000u l=150000u
X7 _s1 A VPWR VPB sky130_fd_pr__pfet_01v8_hvt w=1000000u l=150000u
X8 Y D VPWR VPB sky130_fd_pr__pfet_01v8_hvt w=1000000u l=150000u
X9 Y _s1 p1 VPB sky130_fd_pr__pfet_01v8_hvt w=1000000u l=150000u
X10 Y B p1 VPB sky130_fd_pr__pfet_01v8_hvt w=1000000u l=150000u
X11 p1 C VPWR VPB sky130_fd_pr__pfet_01v8_hvt w=1000000u l=150000u
X12 p1 _s1 p2 VPB sky130_fd_pr__pfet_01v8_hvt w=1000000u l=150000u
X13 p2 B VPWR VPB sky130_fd_pr__pfet_01v8_hvt w=1000000u l=150000u
.ends
