* NGSPICE file created from dd2_g4__n4_2bff_1.ext - technology: sky130A

.subckt dd2_g4__n4_2bff_1 A B C D VGND VNB VPB VPWR Y
X0 VPWR.t3 A.t1 a_51_47.t0 VPB.t1 sky130_fd_pr__pfet_01v8_hvt ad=0.175 pd=1.35 as=0.26 ps=2.52 w=1 l=0.15 sa=0.26 sb=3.68
X1 a_233_47.t1 B.t1 VGND.t1 VNB.t4 sky130_fd_pr__nfet_01v8 ad=0.11375 pd=1 as=0.11375 ps=1 w=0.65 l=0.15 sa=0.76 sb=0.76
X2 Y.t1 D.t0 a_333_47.t2 VNB.t6 sky130_fd_pr__nfet_01v8 ad=0.169 pd=1.82 as=0.11375 ps=1 w=0.65 l=0.15 sa=1.74 sb=0.26
X3 VPWR.t2 C.t1 a_333_297.t0 VPB.t0 sky130_fd_pr__pfet_01v8_hvt ad=0.175 pd=1.35 as=0.175 ps=1.35 w=1 l=0.15 sa=3.18 sb=0.76
X4 VGND.t3 a_51_47.t2 a_439_47.t1 VNB.t3 sky130_fd_pr__nfet_01v8 ad=0.10725 pd=0.98 as=0.169 ps=1.82 w=0.65 l=0.15 sa=0.26 sb=1.74
X5 a_333_297.t2 a_51_47.t5 a_233_297.t0 VPB.t3 sky130_fd_pr__pfet_01v8_hvt ad=0.395 pd=1.79 as=0.175 ps=1.35 w=1 l=0.15 sa=1.26 sb=2.68
X6 VGND.t2 A.t0 a_51_47.t1 VNB.t1 sky130_fd_pr__nfet_01v8 ad=0.11375 pd=1 as=0.169 ps=1.82 w=0.65 l=0.15 sa=0.26 sb=1.26
X7 a_333_47.t0 C.t0 a_439_47.t0 VNB.t0 sky130_fd_pr__nfet_01v8 ad=0.11375 pd=1 as=0.11375 ps=1 w=0.65 l=0.15 sa=1.24 sb=0.76
X8 Y.t3 a_51_47.t4 a_333_297.t1 VPB.t2 sky130_fd_pr__pfet_01v8_hvt ad=0.165 pd=1.33 as=0.395 ps=1.79 w=1 l=0.15 sa=2.2 sb=1.74
X9 a_333_297.t3 B.t2 Y.t2 VPB.t5 sky130_fd_pr__pfet_01v8_hvt ad=0.175 pd=1.35 as=0.165 ps=1.33 w=1 l=0.15 sa=2.68 sb=1.26
X10 a_439_47.t2 B.t0 VGND.t0 VNB.t5 sky130_fd_pr__nfet_01v8 ad=0.11375 pd=1 as=0.10725 ps=0.98 w=0.65 l=0.15 sa=0.74 sb=1.26
X11 a_233_297.t1 B.t3 VPWR.t1 VPB.t4 sky130_fd_pr__pfet_01v8_hvt ad=0.175 pd=1.35 as=0.175 ps=1.35 w=1 l=0.15 sa=0.76 sb=3.18
X12 Y.t0 D.t1 VPWR.t0 VPB.t6 sky130_fd_pr__pfet_01v8_hvt ad=0.26 pd=2.52 as=0.175 ps=1.35 w=1 l=0.15 sa=3.68 sb=0.26
X13 a_333_47.t1 a_51_47.t3 a_233_47.t0 VNB.t2 sky130_fd_pr__nfet_01v8 ad=0.169 pd=1.82 as=0.11375 ps=1 w=0.65 l=0.15 sa=1.26 sb=0.26
R0 VGND VGND.n0 0.195497
R1 VGND.n0 VGND.n1 220.109
R2 VGND.n0 VGND.n2 132.404
R3 VGND.n2 VGND.t2 32.3082
R4 VGND.n2 VGND.t1 32.3082
R5 VGND.n1 VGND.t3 30.462
R6 VGND.n1 VGND.t0 30.462
R7 Y Y.n4 6.8005
R8 Y Y.n4 3.2005
R9 Y.n4 Y.n0 0.2005
R10 Y.n1 Y.n3 31.3486
R11 Y.n0 Y.n1 68.3417
R12 Y.n3 Y.n2 585
R13 Y Y.n3 6.4005
R14 Y.n2 Y.t3 32.5055
R15 Y.n2 Y.t2 32.5055
R16 Y.n1 Y.t0 227.356
R17 Y.n0 Y.t1 268.077
R18 VPWR VPWR.n0 0.186148
R19 VPWR.n0 VPWR.n2 243.35
R20 VPWR.n2 VPWR.t2 34.4755
R21 VPWR.n2 VPWR.t0 34.4755
R22 VPWR.n0 VPWR.n1 618.927
R23 VPWR.n1 VPWR.t3 34.4755
R24 VPWR.n1 VPWR.t1 34.4755
R25 D D.n0 158.4
R26 D.n0 D.t0 169.237
R27 D.n0 D.t1 241.536
R28 C C.n0 158.4
R29 C.n0 C.t0 169.237
R30 C.n0 C.t1 241.536
R31 B.n1 B.n0 152
R32 B B.n1 6.4005
R33 B.n3 B.n1 25.5806
R34 B B.n3 0.376971
R35 B.n3 B.n2 158.024
R36 B.n2 B.t0 169.237
R37 B.n2 B.t2 241.536
R38 B.n0 B.t1 169.237
R39 B.n0 B.t3 241.536
R40 A A.n0 158.4
R41 A.n0 A.t0 169.237
R42 A.n0 A.t1 241.536
R43 VPB VPB.t1 263.397
R44 VPB.t1 VPB.t4 295.95
R45 VPB.t4 VPB.t3 295.95
R46 VPB.t3 VPB.t2 556.386
R47 VPB.t2 VPB.t5 284.113
R48 VPB.t5 VPB.t0 295.95
R49 VPB.t0 VPB.t6 295.95
R50 VNB VNB.t1 1267.31
R51 VNB.t1 VNB.t4 1423.95
R52 VNB.t4 VNB.t2 1423.95
R53 VNB.t2 VNB.t3 2677.02
R54 VNB.t3 VNB.t5 1366.99
R55 VNB.t5 VNB.t0 1423.95
R56 VNB.t0 VNB.t6 1423.95
R57 a_439_47.n0 a_439_47.t1 291.462
R58 a_439_47.n0 a_439_47.t2 32.3082
R59 a_439_47.t0 a_439_47.n0 32.3082
R60 a_333_47.n0 a_333_47.t1 250.285
R61 a_333_47.t0 a_333_47.n0 32.3082
R62 a_333_47.n0 a_333_47.t2 32.3082
R63 a_233_47.t0 a_233_47.t1 64.6159
R64 a_333_297.n0 a_333_297.n1 573.062
R65 a_333_297.n0 a_333_297.t3 34.4755
R66 a_333_297.t0 a_333_297.n0 34.4755
R67 a_333_297.n1 a_333_297.t2 77.8155
R68 a_333_297.n1 a_333_297.t1 77.8155
R69 a_233_297.t0 a_233_297.t1 68.9505
R70 a_51_47.t0 a_51_47.n2 228.773
R71 a_51_47.n2 a_51_47.t1 154.12
R72 a_51_47.n2 a_51_47.n1 257.05
R73 a_51_47.n1 a_51_47.n0 137.298
R74 a_51_47.n1 a_51_47.t5 212.081
R75 a_51_47.n1 a_51_47.t3 139.78
R76 a_51_47.n0 a_51_47.t4 212.081
R77 a_51_47.n0 a_51_47.t2 139.78
C0 VPB D 0.03482f
C1 A VGND 0.02107f
C2 VPWR A 0.01542f
C3 Y D 0.03978f
C4 VPWR VGND 0.01429f
C5 D B 0.00114f
C6 C VGND 0.01265f
C7 C VPWR 0.02428f
C8 Y VPB 0.02589f
C9 VPB B 0.06062f
C10 Y B 0.03188f
C11 D VGND 0.01568f
C12 VPB A 0.03225f
C13 VPWR D 0.02488f
C14 C D 0.03085f
C15 VPB VGND 0.00918f
C16 Y A 0
C17 VPB VPWR 0.13451f
C18 VPB C 0.031f
C19 A B 0.03342f
C20 Y VGND 0.02415f
C21 Y VPWR 0.13342f
C22 Y C 0.01285f
C23 VGND B 0.05674f
C24 VPWR B 0.05355f
C25 C B 0.03372f
C26 VGND VNB 0.11206f
C27 Y VNB 0f
C28 VPWR VNB 0f
C29 D VNB 0.05178f
C30 C VNB 0.0204f
C31 B VNB 0f
C32 A VNB 0.05821f
C33 VPB VNB 0.59471f
C34 a_51_47.t0 VNB 0.09011f
C35 a_51_47.n0 VNB 0.06859f
C36 a_51_47.n1 VNB 0.09487f
C37 a_51_47.n2 VNB 0.2488f
C38 a_51_47.t1 VNB 0.06532f
C39 a_233_297.t0 VNB 0.03805f
C40 a_233_297.t1 VNB 0.0503f
C41 a_333_297.t0 VNB 0.04627f
C42 a_333_297.n0 VNB 0.07458f
C43 a_333_297.n1 VNB 0.13962f
C44 a_333_297.t2 VNB 0.05642f
C45 a_333_297.t1 VNB 0.05642f
C46 a_333_297.t3 VNB 0.04774f
C47 a_233_47.t0 VNB 0.02905f
C48 a_233_47.t1 VNB 0.03833f
C49 a_333_47.t0 VNB 0.04117f
C50 a_333_47.n0 VNB 0.21046f
C51 a_333_47.t1 VNB 0.18472f
C52 a_333_47.t2 VNB 0.03848f
C53 a_439_47.t0 VNB 0.03961f
C54 a_439_47.n0 VNB 0.12542f
C55 a_439_47.t1 VNB 0.12564f
C56 a_439_47.t2 VNB 0.04068f
C57 VPB.t0 VNB 0.04715f
C58 VPB.t1 VNB 0.04455f
C59 VPB.t2 VNB 0.06695f
C60 VPB.t3 VNB 0.06789f
C61 VPB.t4 VNB 0.04715f
C62 VPB.t5 VNB 0.0462f
C63 VPB.t6 VNB 0.09712f
C64 A.n0 VNB 0.05163f
C65 B.n0 VNB 0.06226f
C66 B.n1 VNB 0.08571f
C67 B.n2 VNB 0.0628f
C68 B.n3 VNB 0.13722f
C69 C.n0 VNB 0.05987f
C70 D.n0 VNB 0.05235f
C71 VPWR.n0 VNB 0.46446f
C72 VPWR.t3 VNB 0.03978f
C73 VPWR.t1 VNB 0.04533f
C74 VPWR.n1 VNB 0.02929f
C75 VPWR.n2 VNB 0.0356f
C76 VPWR.t2 VNB 0.04386f
C77 VPWR.t0 VNB 0.04014f
C78 Y.t1 VNB 0.05382f
C79 Y.n0 VNB 0.03165f
C80 Y.t0 VNB 0.08303f
C81 Y.n1 VNB 0.12649f
C82 Y.t3 VNB 0.03814f
C83 Y.t2 VNB 0.05039f
C84 Y.n2 VNB 0.03859f
C85 Y.n3 VNB 0.05074f
C86 Y.n4 VNB 0.00795f
C87 VGND.n0 VNB 0.35998f
C88 VGND.t3 VNB 0.02042f
C89 VGND.t0 VNB 0.0297f
C90 VGND.n1 VNB 0.01697f
C91 VGND.n2 VNB 0.02115f
C92 VGND.t2 VNB 0.02612f
C93 VGND.t1 VNB 0.03013f
.ends
