.subckt dd2_g4__n4_008e_1 A B C D VGND VNB VPB VPWR Y
X0 _s1 B VGND VNB sky130_fd_pr__nfet_01v8 w=650000u l=150000u
X1 _s2 A VGND VNB sky130_fd_pr__nfet_01v8 w=650000u l=150000u
X2 Y D VGND VNB sky130_fd_pr__nfet_01v8 w=650000u l=150000u
X3 Y _s1 n1 VNB sky130_fd_pr__nfet_01v8 w=650000u l=150000u
X4 Y _s2 n1 VNB sky130_fd_pr__nfet_01v8 w=650000u l=150000u
X5 n1 C VGND VNB sky130_fd_pr__nfet_01v8 w=650000u l=150000u
X6 n1 _s1 n2 VNB sky130_fd_pr__nfet_01v8 w=650000u l=150000u
X7 n2 _s2 VGND VNB sky130_fd_pr__nfet_01v8 w=650000u l=150000u
X8 _s1 B VPWR VPB sky130_fd_pr__pfet_01v8_hvt w=1000000u l=150000u
X9 _s2 A VPWR VPB sky130_fd_pr__pfet_01v8_hvt w=1000000u l=150000u
X10 Y D p1 VPB sky130_fd_pr__pfet_01v8_hvt w=1000000u l=150000u
X11 p1 _s1 p2 VPB sky130_fd_pr__pfet_01v8_hvt w=1000000u l=150000u
X12 p2 _s2 VPWR VPB sky130_fd_pr__pfet_01v8_hvt w=1000000u l=150000u
X13 p1 C p3 VPB sky130_fd_pr__pfet_01v8_hvt w=1000000u l=150000u
X14 p3 _s1 VPWR VPB sky130_fd_pr__pfet_01v8_hvt w=1000000u l=150000u
X15 p3 _s2 VPWR VPB sky130_fd_pr__pfet_01v8_hvt w=1000000u l=150000u
.ends
