* NGSPICE file created from dd2_g4__n4_008e_1.ext - technology: sky130A

.subckt dd2_g4__n4_008e_1 A B C D VGND VNB VPB VPWR Y
X0 Y.t1 a_114_47.t2 a_570_47.t3 VNB.t7 sky130_fd_pr__nfet_01v8 ad=0.08775 pd=0.92 as=0.25675 ps=1.44 w=0.65 l=0.15 sa=2.54 sb=2.02
X1 a_570_297.t1 C.t1 a_676_297.t2 VPB.t6 sky130_fd_pr__pfet_01v8_hvt ad=0.2025 pd=1.405 as=0.3175 ps=1.635 w=1 l=0.15 sa=1.465 sb=0.815
X2 a_570_47.t0 a_114_47.t3 a_413_47.t0 VNB.t0 sky130_fd_pr__nfet_01v8 ad=0.25675 pd=1.44 as=0.20638 ps=1.285 w=0.65 l=0.15 sa=1.6 sb=2.96
X3 VGND.t1 C.t0 a_570_47.t2 VNB.t5 sky130_fd_pr__nfet_01v8 ad=0.13162 pd=1.055 as=0.20638 ps=1.285 w=0.65 l=0.15 sa=3.745 sb=0.815
X4 a_570_297.t0 a_114_47.t5 a_413_297.t1 VPB.t3 sky130_fd_pr__pfet_01v8_hvt ad=0.26 pd=2.52 as=0.3175 ps=1.635 w=1 l=0.15 sa=1.6 sb=0.26
X5 a_114_47.t1 B.t0 VGND.t3 VNB.t4 sky130_fd_pr__nfet_01v8 ad=0.169 pd=1.82 as=0.169 ps=1.82 w=0.65 l=0.15 sa=0.26 sb=0.26
X6 a_413_47.t1 a_220_47.t3 VGND.t2 VNB.t2 sky130_fd_pr__nfet_01v8 ad=0.20638 pd=1.285 as=0.13162 ps=1.055 w=0.65 l=0.15 sa=0.815 sb=3.745
X7 a_413_297.t0 a_220_47.t5 VPWR.t4 VPB.t2 sky130_fd_pr__pfet_01v8_hvt ad=0.3175 pd=1.635 as=0.2025 ps=1.405 w=1 l=0.15 sa=0.815 sb=1.045
X8 VGND.t0 A.t0 a_220_47.t1 VNB.t3 sky130_fd_pr__nfet_01v8 ad=0.13162 pd=1.055 as=0.169 ps=1.82 w=0.65 l=0.15 sa=0.26 sb=4.3
X9 a_676_297.t1 a_220_47.t4 VPWR.t3 VPB.t1 sky130_fd_pr__pfet_01v8_hvt ad=0.3175 pd=1.635 as=0.135 ps=1.27 w=1 l=0.15 sa=0.68 sb=1.6
X10 Y.t3 D.t0 VGND.t4 VNB.t6 sky130_fd_pr__nfet_01v8 ad=0.169 pd=1.82 as=0.13162 ps=1.055 w=0.65 l=0.15 sa=4.3 sb=0.26
X11 VPWR.t2 a_114_47.t4 a_676_297.t0 VPB.t0 sky130_fd_pr__pfet_01v8_hvt ad=0.135 pd=1.27 as=0.26 ps=2.52 w=1 l=0.15 sa=0.26 sb=2.02
X12 VPWR.t0 A.t1 a_220_47.t0 VPB.t4 sky130_fd_pr__pfet_01v8_hvt ad=0.2025 pd=1.405 as=0.26 ps=2.52 w=1 l=0.15 sa=0.26 sb=1.6
X13 a_114_47.t0 B.t1 VPWR.t1 VPB.t5 sky130_fd_pr__pfet_01v8_hvt ad=0.26 pd=2.52 as=0.26 ps=2.52 w=1 l=0.15 sa=0.26 sb=0.26
X14 Y.t2 D.t1 a_570_297.t2 VPB.t7 sky130_fd_pr__pfet_01v8_hvt ad=0.26 pd=2.52 as=0.2025 ps=1.405 w=1 l=0.15 sa=2.02 sb=0.26
X15 a_570_47.t1 a_220_47.t2 Y.t0 VNB.t1 sky130_fd_pr__nfet_01v8 ad=0.20638 pd=1.285 as=0.08775 ps=0.92 w=0.65 l=0.15 sa=2.96 sb=1.6
R0 VGND.n1 VGND.n0 9.3005
R1 VGND.n3 VGND.n2 9.3005
R2 VGND.n5 VGND.n4 9.3005
R3 VGND VGND.n11 0.0226354
R4 VGND.n11 VGND.n1 0.120292
R5 VGND.n1 VGND.n3 0.120292
R6 VGND.n3 VGND.n5 0.120292
R7 VGND.n5 VGND.n6 0.147278
R8 VGND.n6 VGND.n7 218.379
R9 VGND.n11 VGND.n10 13.4417
R10 VGND.n10 VGND.n0 30.4946
R11 VGND.n0 VGND.n2 34.6358
R12 VGND.n2 VGND.n4 34.6358
R13 VGND.n4 VGND.n9 7.90638
R14 VGND.n9 VGND.n6 34.3304
R15 VGND.n10 VGND.t3 290.289
R16 VGND.n9 VGND.n8 207.213
R17 VGND.n8 VGND.t0 37.8467
R18 VGND.n8 VGND.t2 36.9236
R19 VGND.n7 VGND.t1 36.9236
R20 VGND.n7 VGND.t4 37.8467
R21 Y Y.n5 6.8005
R22 Y.n1 Y.n0 185
R23 Y Y.n5 4.45267
R24 Y.n5 Y.n1 0.278761
R25 Y.n1 Y.n4 98.7831
R26 Y.n4 Y.t2 401.692
R27 Y.n3 Y 6.4005
R28 Y Y.n2 6.4005
R29 Y.n4 Y.n2 22.5887
R30 Y Y.n3 2.25932
R31 Y.t3 Y.n3 271.647
R32 Y.n2 Y.t3 268.077
R33 Y.n0 Y.t1 24.9236
R34 Y.n0 Y.t0 24.9236
R35 VPWR.n2 VPWR.n1 9.3005
R36 VPWR.n4 VPWR.n3 9.3005
R37 VPWR.n6 VPWR.n5 9.3005
R38 VPWR VPWR.n0 0.0226354
R39 VPWR.n0 VPWR.n2 0.120292
R40 VPWR.n2 VPWR.n4 0.120292
R41 VPWR.n4 VPWR.n6 0.120292
R42 VPWR.n6 VPWR.n7 0.154943
R43 VPWR.n7 VPWR.n11 614.84
R44 VPWR.n0 VPWR.n8 13.4417
R45 VPWR.n8 VPWR.n1 30.4946
R46 VPWR.n1 VPWR.n3 34.6358
R47 VPWR.n3 VPWR.n5 34.6358
R48 VPWR.n5 VPWR.n10 7.90638
R49 VPWR.n10 VPWR.n7 34.3228
R50 VPWR.n11 VPWR.t2 26.5955
R51 VPWR.n11 VPWR.t3 26.5955
R52 VPWR.n10 VPWR.n9 607.212
R53 VPWR.n9 VPWR.t0 40.3855
R54 VPWR.n9 VPWR.t4 39.4005
R55 VPWR.n8 VPWR.t1 876.193
R56 D D.n0 158.4
R57 D.n0 D.t0 158.064
R58 D.n0 D.t1 230.363
R59 C C.n0 158.4
R60 C.n0 C.t0 169.237
R61 C.n0 C.t1 241.536
R62 A A.n0 158.4
R63 A.n0 A.t0 169.237
R64 A.n0 A.t1 241.536
R65 B B.n0 158.4
R66 B.n0 B.t0 158.064
R67 B.n0 B.t1 230.363
R68 VPB VPB.t5 207.166
R69 VPB.t5 VPB.t4 556.386
R70 VPB.t4 VPB.t2 328.505
R71 VPB.t2 VPB.t3 464.642
R72 VPB.t3 VPB.t0 556.386
R73 VPB.t0 VPB.t1 248.599
R74 VPB.t1 VPB.t6 464.642
R75 VPB.t6 VPB.t7 328.505
R76 VNB VNB.t4 996.764
R77 VNB.t4 VNB.t3 2677.02
R78 VNB.t3 VNB.t2 1580.58
R79 VNB.t2 VNB.t0 2235.6
R80 VNB.t0 VNB.t7 2677.02
R81 VNB.t7 VNB.t1 1196.12
R82 VNB.t1 VNB.t5 2235.6
R83 VNB.t5 VNB.t6 1580.58
R84 a_570_47.t0 a_570_47.n0 72.9236
R85 a_570_47.n0 a_570_47.t3 72.9236
R86 a_570_47.n0 a_570_47.n1 466.377
R87 a_570_47.n1 a_570_47.t1 58.1543
R88 a_570_47.n1 a_570_47.t2 59.0774
R89 a_413_47.t0 a_413_47.t1 117.231
R90 a_676_297.t0 a_676_297.n0 996.856
R91 a_676_297.n0 a_676_297.t1 62.0555
R92 a_676_297.n0 a_676_297.t2 63.0405
R93 a_570_297.t0 a_570_297.n0 697.423
R94 a_570_297.n0 a_570_297.t1 39.4005
R95 a_570_297.n0 a_570_297.t2 40.3855
R96 a_413_297.t0 a_413_297.t1 125.096
R97 a_114_47.t0 a_114_47.n0 278.091
R98 a_114_47.n0 a_114_47.t1 173.845
R99 a_114_47.n0 a_114_47.n2 186.656
R100 a_114_47.n2 a_114_47.n1 137.298
R101 a_114_47.n2 a_114_47.t5 212.081
R102 a_114_47.n2 a_114_47.t3 139.78
R103 a_114_47.n1 a_114_47.t4 212.081
R104 a_114_47.n1 a_114_47.t2 139.78
R105 a_220_47.t0 a_220_47.n1 316.113
R106 a_220_47.n1 a_220_47.n0 152
R107 a_220_47.n1 a_220_47.n3 25.6005
R108 a_220_47.n3 a_220_47.n2 325.93
R109 a_220_47.n2 a_220_47.t2 158.064
R110 a_220_47.n2 a_220_47.t4 230.363
R111 a_220_47.n3 a_220_47.t1 193.728
R112 a_220_47.n0 a_220_47.t3 158.064
R113 a_220_47.n0 a_220_47.t5 230.363
C0 VGND VPWR 0.03513f
C1 VPB A 0.03354f
C2 B VPB 0.04395f
C3 Y D 0.0748f
C4 D C 0.01709f
C5 Y VPB 0.01596f
C6 VPB C 0.0321f
C7 D VPWR 0.01482f
C8 D VGND 0.01657f
C9 B A 0.01709f
C10 VPB VPWR 0.16689f
C11 VPB VGND 0.01225f
C12 Y A 0
C13 VPWR A 0.01457f
C14 VGND A 0.01329f
C15 B VPWR 0.01528f
C16 Y C 0.03639f
C17 B VGND 0.01439f
C18 D VPB 0.04115f
C19 Y VPWR 0.02189f
C20 VPWR C 0.01115f
C21 Y VGND 0.08076f
C22 VGND C 0.01603f
C23 VGND VNB 0.02653f
C24 Y VNB 0f
C25 VPWR VNB 0f
C26 D VNB 0.05952f
C27 C VNB 0.02713f
C28 A VNB 0.03029f
C29 B VNB 0.04973f
C30 VPB VNB 0.72168f
C31 a_220_47.t0 VNB 0.14838f
C32 a_220_47.n0 VNB 0.07073f
C33 a_220_47.n1 VNB 0.15149f
C34 a_220_47.t1 VNB 0.09308f
C35 a_220_47.n2 VNB 0.11395f
C36 a_220_47.n3 VNB 0.20515f
C37 a_114_47.t0 VNB 0.12284f
C38 a_114_47.n0 VNB 0.37962f
C39 a_114_47.n1 VNB 0.08061f
C40 a_114_47.n2 VNB 0.10407f
C41 a_114_47.t1 VNB 0.07975f
C42 a_413_297.t0 VNB 0.06068f
C43 a_413_297.t1 VNB 0.05755f
C44 a_570_297.t0 VNB 0.22324f
C45 a_570_297.n0 VNB 0.16031f
C46 a_570_297.t1 VNB 0.05529f
C47 a_570_297.t2 VNB 0.05257f
C48 a_676_297.t0 VNB 0.12961f
C49 a_676_297.t1 VNB 0.05723f
C50 a_676_297.t2 VNB 0.06028f
C51 a_676_297.n0 VNB 0.09627f
C52 a_413_47.t0 VNB 0.03674f
C53 a_413_47.t1 VNB 0.03946f
C54 a_570_47.t0 VNB 0.04035f
C55 a_570_47.n0 VNB 0.07612f
C56 a_570_47.t1 VNB 0.03804f
C57 a_570_47.t2 VNB 0.04023f
C58 a_570_47.n1 VNB 0.06638f
C59 a_570_47.t3 VNB 0.04035f
C60 VPB.t0 VNB 0.06409f
C61 VPB.t1 VNB 0.05678f
C62 VPB.t2 VNB 0.06314f
C63 VPB.t3 VNB 0.08129f
C64 VPB.t4 VNB 0.07045f
C65 VPB.t5 VNB 0.06079f
C66 VPB.t6 VNB 0.06314f
C67 VPB.t7 VNB 0.09165f
C68 B.n0 VNB 0.07714f
C69 A.n0 VNB 0.05829f
C70 C.n0 VNB 0.05622f
C71 D.n0 VNB 0.0688f
C72 VPWR.n0 VNB 0.0215f
C73 VPWR.n1 VNB 0.01096f
C74 VPWR.n2 VNB 0.0329f
C75 VPWR.n3 VNB 0.01165f
C76 VPWR.n4 VNB 0.0329f
C77 VPWR.n5 VNB 0.00716f
C78 VPWR.n6 VNB 0.05733f
C79 VPWR.n7 VNB 0.38322f
C80 VPWR.t1 VNB 0.0625f
C81 VPWR.n8 VNB 0.02563f
C82 VPWR.t0 VNB 0.04412f
C83 VPWR.t4 VNB 0.04018f
C84 VPWR.n9 VNB 0.03046f
C85 VPWR.n10 VNB 0.02003f
C86 VPWR.t2 VNB 0.03221f
C87 VPWR.t3 VNB 0.03534f
C88 VPWR.n11 VNB 0.02094f
C89 Y.t1 VNB 0.02758f
C90 Y.t0 VNB 0.0303f
C91 Y.n0 VNB 0.02411f
C92 Y.n1 VNB 0.03531f
C93 Y.t3 VNB 0.05448f
C94 Y.n2 VNB 0.01737f
C95 Y.n3 VNB 0.04701f
C96 Y.t2 VNB 0.10301f
C97 Y.n4 VNB 0.11024f
C98 Y.n5 VNB 0.00829f
C99 VGND.n0 VNB 0.00914f
C100 VGND.n1 VNB 0.02744f
C101 VGND.n2 VNB 0.00972f
C102 VGND.n3 VNB 0.02744f
C103 VGND.n4 VNB 0.00597f
C104 VGND.n5 VNB 0.03376f
C105 VGND.n6 VNB 0.33195f
C106 VGND.t1 VNB 0.02819f
C107 VGND.t4 VNB 0.0259f
C108 VGND.n7 VNB 0.01873f
C109 VGND.t0 VNB 0.02913f
C110 VGND.t2 VNB 0.02632f
C111 VGND.n8 VNB 0.01707f
C112 VGND.n9 VNB 0.01625f
C113 VGND.t3 VNB 0.0391f
C114 VGND.n10 VNB 0.02001f
C115 VGND.n11 VNB 0.01793f
.ends
