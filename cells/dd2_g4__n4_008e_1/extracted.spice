* NGSPICE file created from dd2_g4__n4_008e_1.ext - technology: sky130A

.subckt dd2_g4__n4_008e_1 A B C D VGND VNB VPB VPWR Y
X0 Y a_114_47# a_570_47# VNB sky130_fd_pr__nfet_01v8 ad=0.08775 pd=0.92 as=0.25675 ps=1.44 w=0.65 l=0.15
X1 a_570_297# C a_676_297# VPB sky130_fd_pr__pfet_01v8_hvt ad=0.2025 pd=1.405 as=0.3175 ps=1.635 w=1 l=0.15
X2 a_570_47# a_114_47# a_413_47# VNB sky130_fd_pr__nfet_01v8 ad=0.25675 pd=1.44 as=0.20638 ps=1.285 w=0.65 l=0.15
X3 VGND C a_570_47# VNB sky130_fd_pr__nfet_01v8 ad=0.13162 pd=1.055 as=0.20638 ps=1.285 w=0.65 l=0.15
X4 a_570_297# a_114_47# a_413_297# VPB sky130_fd_pr__pfet_01v8_hvt ad=0.26 pd=2.52 as=0.3175 ps=1.635 w=1 l=0.15
X5 a_114_47# B VGND VNB sky130_fd_pr__nfet_01v8 ad=0.169 pd=1.82 as=0.169 ps=1.82 w=0.65 l=0.15
X6 a_413_47# a_220_47# VGND VNB sky130_fd_pr__nfet_01v8 ad=0.20638 pd=1.285 as=0.13162 ps=1.055 w=0.65 l=0.15
X7 a_413_297# a_220_47# VPWR VPB sky130_fd_pr__pfet_01v8_hvt ad=0.3175 pd=1.635 as=0.2025 ps=1.405 w=1 l=0.15
X8 VGND A a_220_47# VNB sky130_fd_pr__nfet_01v8 ad=0.13162 pd=1.055 as=0.169 ps=1.82 w=0.65 l=0.15
X9 a_676_297# a_220_47# VPWR VPB sky130_fd_pr__pfet_01v8_hvt ad=0.3175 pd=1.635 as=0.135 ps=1.27 w=1 l=0.15
X10 Y D VGND VNB sky130_fd_pr__nfet_01v8 ad=0.169 pd=1.82 as=0.13162 ps=1.055 w=0.65 l=0.15
X11 VPWR a_114_47# a_676_297# VPB sky130_fd_pr__pfet_01v8_hvt ad=0.135 pd=1.27 as=0.26 ps=2.52 w=1 l=0.15
X12 VPWR A a_220_47# VPB sky130_fd_pr__pfet_01v8_hvt ad=0.2025 pd=1.405 as=0.26 ps=2.52 w=1 l=0.15
X13 a_114_47# B VPWR VPB sky130_fd_pr__pfet_01v8_hvt ad=0.26 pd=2.52 as=0.26 ps=2.52 w=1 l=0.15
X14 Y D a_570_297# VPB sky130_fd_pr__pfet_01v8_hvt ad=0.26 pd=2.52 as=0.2025 ps=1.405 w=1 l=0.15
X15 a_570_47# a_220_47# Y VNB sky130_fd_pr__nfet_01v8 ad=0.20638 pd=1.285 as=0.08775 ps=0.92 w=0.65 l=0.15
.ends
