* NGSPICE file created from dd2_g4__n3_8e_1.ext - technology: sky130A

.subckt dd2_g4__n3_8e_1 A B C VGND VNB VPB VPWR Y
X0 a_529_47.t1 A.t1 VGND.t1 VNB.t5 sky130_fd_pr__nfet_01v8 ad=0.08775 pd=0.92 as=0.26 ps=1.45 w=0.65 l=0.15 sa=1.21 sb=3
X1 a_309_21.t0 C.t1 VPWR.t0 VPB.t2 sky130_fd_pr__pfet_01v8_hvt ad=0.26 pd=2.52 as=0.26 ps=2.52 w=1 l=0.15 sa=0.26 sb=0.26
X2 a_257_47.t0 B.t0 a_64_199.t2 VNB.t1 sky130_fd_pr__nfet_01v8 ad=0.08775 pd=0.92 as=0.26 ps=1.45 w=0.65 l=0.15 sa=2.58 sb=1.63
X3 Y.t1 a_64_199.t5 VPWR.t2 VPB.t0 sky130_fd_pr__pfet_01v8_hvt ad=0.26 pd=2.52 as=0.26 ps=2.52 w=1 l=0.15 sa=0.26 sb=0.26
X4 a_257_297.t1 A.t2 VPWR.t3 VPB.t6 sky130_fd_pr__pfet_01v8_hvt ad=0.26 pd=2.52 as=0.135 ps=1.27 w=1 l=0.15 sa=3 sb=0.26
X5 VGND.t4 A.t0 a_257_47.t2 VNB.t6 sky130_fd_pr__nfet_01v8 ad=0.26 pd=1.45 as=0.08775 ps=0.92 w=0.65 l=0.15 sa=3 sb=1.21
X6 VPWR.t1 B.t1 a_339_297.t0 VPB.t1 sky130_fd_pr__pfet_01v8_hvt ad=0.135 pd=1.27 as=0.4 ps=1.8 w=1 l=0.15 sa=2.58 sb=0.68
X7 a_339_297.t2 a_309_21.t5 a_257_297.t0 VPB.t4 sky130_fd_pr__pfet_01v8_hvt ad=0.4 pd=1.8 as=0.26 ps=2.52 w=1 l=0.15 sa=0.26 sb=3
X8 a_309_21.t1 C.t0 VGND.t0 VNB.t2 sky130_fd_pr__nfet_01v8 ad=0.169 pd=1.82 as=0.26 ps=1.45 w=0.65 l=0.15 sa=3.95 sb=0.26
X9 VGND.t3 a_309_21.t3 a_257_47.t1 VNB.t3 sky130_fd_pr__nfet_01v8 ad=0.26 pd=1.45 as=0.169 ps=1.82 w=0.65 l=0.15 sa=0.26 sb=3.95
X10 a_339_297.t1 a_309_21.t4 a_64_199.t1 VPB.t3 sky130_fd_pr__pfet_01v8_hvt ad=0.4 pd=1.8 as=0.135 ps=1.27 w=1 l=0.15 sa=1.63 sb=1.63
X11 a_64_199.t0 a_309_21.t2 a_529_47.t0 VNB.t4 sky130_fd_pr__nfet_01v8 ad=0.26 pd=1.45 as=0.08775 ps=0.92 w=0.65 l=0.15 sa=1.63 sb=2.58
X12 Y.t0 a_64_199.t4 VGND.t2 VNB.t0 sky130_fd_pr__nfet_01v8 ad=0.169 pd=1.82 as=0.169 ps=1.82 w=0.65 l=0.15 sa=0.26 sb=0.26
X13 a_64_199.t3 A.t3 a_339_297.t3 VPB.t5 sky130_fd_pr__pfet_01v8_hvt ad=0.135 pd=1.27 as=0.4 ps=1.8 w=1 l=0.15 sa=1.21 sb=2.05
R0 VGND.n1 VGND.n0 9.3005
R1 VGND.n3 VGND.n2 9.3005
R2 VGND.n5 VGND.n4 9.3005
R3 VGND.n7 VGND.n6 9.3005
R4 VGND VGND.n13 0.0226354
R5 VGND.n13 VGND.n1 0.120292
R6 VGND.n1 VGND.n3 0.120292
R7 VGND.n3 VGND.n5 0.120292
R8 VGND.n5 VGND.n7 0.120292
R9 VGND.n7 VGND.n8 0.148609
R10 VGND.n8 VGND.n9 127.953
R11 VGND.n13 VGND.n12 27.3711
R12 VGND.n0 VGND.n12 16.5652
R13 VGND.n0 VGND.n2 34.6358
R14 VGND.n2 VGND.n4 34.6358
R15 VGND.n4 VGND.n6 34.6358
R16 VGND.n6 VGND.n11 1.88285
R17 VGND.n11 VGND.n8 40.3526
R18 VGND.n12 VGND.t2 160.222
R19 VGND.n11 VGND.n10 207.213
R20 VGND.n10 VGND.t3 73.8467
R21 VGND.n10 VGND.t1 73.8467
R22 VGND.n9 VGND.t4 73.8467
R23 VGND.n9 VGND.t0 73.8467
R24 Y.n1 Y.n0 20.7374
R25 Y.n1 Y.t1 228.772
R26 Y Y.n1 3.29747
R27 Y Y.n0 1.64144
R28 Y.n0 Y.t0 133.386
R29 VPWR.n2 VPWR.n1 9.3005
R30 VPWR.n4 VPWR.n3 9.3005
R31 VPWR.n6 VPWR.n5 9.3005
R32 VPWR.n8 VPWR.n7 9.3005
R33 VPWR.n10 VPWR.n9 9.3005
R34 VPWR.n12 VPWR.n11 9.3005
R35 VPWR.n14 VPWR.n13 9.3005
R36 VPWR.n16 VPWR.n15 9.3005
R37 VPWR VPWR.n0 0.0226354
R38 VPWR.n0 VPWR.n2 0.120292
R39 VPWR.n2 VPWR.n4 0.120292
R40 VPWR.n4 VPWR.n6 0.120292
R41 VPWR.n6 VPWR.n8 0.120292
R42 VPWR.n8 VPWR.n10 0.120292
R43 VPWR.n10 VPWR.n12 0.120292
R44 VPWR.n12 VPWR.n14 0.120292
R45 VPWR.n14 VPWR.n16 0.120292
R46 VPWR.n16 VPWR.n17 0.857451
R47 VPWR.n17 VPWR.t0 359.291
R48 VPWR.n0 VPWR.n18 27.3711
R49 VPWR.n1 VPWR.n18 16.5652
R50 VPWR.n1 VPWR.n3 34.6358
R51 VPWR.n3 VPWR.n5 34.6358
R52 VPWR.n5 VPWR.n7 34.6358
R53 VPWR.n7 VPWR.n9 34.6358
R54 VPWR.n9 VPWR.n11 34.6358
R55 VPWR.n11 VPWR.n13 34.6358
R56 VPWR.n13 VPWR.n15 34.6358
R57 VPWR.n15 VPWR.n20 18.0711
R58 VPWR.n17 VPWR.n20 23.4556
R59 VPWR.n20 VPWR.n19 607.212
R60 VPWR.n19 VPWR.t1 26.5955
R61 VPWR.n19 VPWR.t3 26.5955
R62 VPWR.n18 VPWR.t2 257.474
R63 C C.n0 158.4
R64 C.n0 C.t0 158.064
R65 C.n0 C.t1 230.363
R66 B B.n0 158.4
R67 B.n0 B.t0 158.064
R68 B.n0 B.t1 230.363
R69 A.n1 A.n0 152
R70 A A.n1 6.4005
R71 A.n3 A.n1 25.7545
R72 A A.n3 0.376971
R73 A.n3 A.n2 158.024
R74 A.n2 A.t0 158.064
R75 A.n2 A.t2 230.363
R76 A.n0 A.t1 158.064
R77 A.n0 A.t3 230.363
R78 VPB VPB.t0 316.668
R79 VPB.t0 VPB.t4 556.386
R80 VPB.t4 VPB.t5 562.306
R81 VPB.t5 VPB.t3 248.599
R82 VPB.t3 VPB.t1 562.306
R83 VPB.t1 VPB.t6 248.599
R84 VPB.t6 VPB.t2 562.306
R85 VNB VNB.t0 1523.62
R86 VNB.t0 VNB.t3 2677.02
R87 VNB.t3 VNB.t5 2705.5
R88 VNB.t5 VNB.t4 1196.12
R89 VNB.t4 VNB.t1 2705.5
R90 VNB.t1 VNB.t6 1196.12
R91 VNB.t6 VNB.t2 2705.5
R92 a_529_47.t0 a_529_47.t1 49.8467
R93 a_257_47.t0 a_257_47.n0 24.9236
R94 a_257_47.n0 a_257_47.t2 24.9236
R95 a_257_47.n0 a_257_47.t1 439.572
R96 a_339_297.n0 a_339_297.t1 78.8005
R97 a_339_297.t0 a_339_297.n0 78.8005
R98 a_339_297.n0 a_339_297.n1 1273.15
R99 a_339_297.n1 a_339_297.t2 78.8005
R100 a_339_297.n1 a_339_297.t3 78.8005
R101 a_257_297.t0 a_257_297.t1 862.725
R102 a_309_21.t0 a_309_21.n3 235.947
R103 a_309_21.n3 a_309_21.t1 193.395
R104 a_309_21.n3 a_309_21.n1 155.107
R105 a_309_21.n1 a_309_21.n2 177.507
R106 a_309_21.n2 a_309_21.t3 158.064
R107 a_309_21.n2 a_309_21.t5 230.363
R108 a_309_21.n1 a_309_21.n0 174.12
R109 a_309_21.n0 a_309_21.t2 158.064
R110 a_309_21.n0 a_309_21.t4 230.363
R111 a_64_199.n0 a_64_199.n3 585
R112 a_64_199.n0 a_64_199.t3 26.5955
R113 a_64_199.t1 a_64_199.n0 26.5955
R114 a_64_199.n3 a_64_199.n2 293.048
R115 a_64_199.n2 a_64_199.t0 73.8467
R116 a_64_199.n2 a_64_199.t2 73.8467
R117 a_64_199.n3 a_64_199.n1 351.906
R118 a_64_199.n1 a_64_199.t4 158.064
R119 a_64_199.n1 a_64_199.t5 230.363
C0 VPWR A 0.04254f
C1 Y VPB 0.01498f
C2 C VGND 0.02865f
C3 A VGND 0.08781f
C4 B A 0.05087f
C5 VPWR VGND 0.03533f
C6 Y C 0
C7 Y A 0
C8 VPWR B 0.01481f
C9 Y VPWR 0.07544f
C10 B VGND 0.00859f
C11 C VPB 0.04457f
C12 A VPB 0.08126f
C13 Y VGND 0.06069f
C14 VPWR VPB 0.18446f
C15 Y B 0
C16 C A 0.02755f
C17 VPB VGND 0.01808f
C18 VPWR C 0.02063f
C19 B VPB 0.039f
C20 VGND VNB 0.02727f
C21 Y VNB 0f
C22 VPWR VNB 0f
C23 C VNB 0.05115f
C24 B VNB 0.01782f
C25 A VNB 0f
C26 VPB VNB 0.73949f
C27 a_64_199.t1 VNB 0.04891f
C28 a_64_199.n0 VNB 0.04478f
C29 a_64_199.n1 VNB 0.12089f
C30 a_64_199.t0 VNB 0.06226f
C31 a_64_199.t2 VNB 0.06396f
C32 a_64_199.n2 VNB 0.10556f
C33 a_64_199.n3 VNB 0.20182f
C34 a_64_199.t3 VNB 0.05374f
C35 a_309_21.t0 VNB 0.1158f
C36 a_309_21.n0 VNB 0.07744f
C37 a_309_21.n1 VNB 0.27056f
C38 a_309_21.n2 VNB 0.08583f
C39 a_309_21.n3 VNB 0.25143f
C40 a_309_21.t1 VNB 0.09418f
C41 a_257_297.t0 VNB 0.28433f
C42 a_257_297.t1 VNB 0.28959f
C43 a_339_297.t0 VNB 0.06401f
C44 a_339_297.n0 VNB 0.09563f
C45 a_339_297.t2 VNB 0.06165f
C46 a_339_297.t3 VNB 0.06648f
C47 a_339_297.n1 VNB 0.09563f
C48 a_339_297.t1 VNB 0.06165f
C49 a_257_47.t0 VNB 0.03894f
C50 a_257_47.n0 VNB 0.22766f
C51 a_257_47.t1 VNB 0.24037f
C52 a_257_47.t2 VNB 0.04073f
C53 a_529_47.t0 VNB 0.02732f
C54 a_529_47.t1 VNB 0.03081f
C55 VPB.t0 VNB 0.06945f
C56 VPB.t1 VNB 0.06451f
C57 VPB.t2 VNB 0.12571f
C58 VPB.t3 VNB 0.06451f
C59 VPB.t4 VNB 0.08899f
C60 VPB.t5 VNB 0.06451f
C61 VPB.t6 VNB 0.06451f
C62 A.n0 VNB 0.08773f
C63 A.n1 VNB 0.09945f
C64 A.n2 VNB 0.08828f
C65 A.n3 VNB 0.15888f
C66 B.n0 VNB 0.08136f
C67 C.n0 VNB 0.07243f
C68 VPWR.n0 VNB 0.02746f
C69 VPWR.n1 VNB 0.00933f
C70 VPWR.n2 VNB 0.03565f
C71 VPWR.n3 VNB 0.01263f
C72 VPWR.n4 VNB 0.03565f
C73 VPWR.n5 VNB 0.01263f
C74 VPWR.n6 VNB 0.03565f
C75 VPWR.n7 VNB 0.01263f
C76 VPWR.n8 VNB 0.03565f
C77 VPWR.n9 VNB 0.01263f
C78 VPWR.n10 VNB 0.03565f
C79 VPWR.n11 VNB 0.01263f
C80 VPWR.n12 VNB 0.03565f
C81 VPWR.n13 VNB 0.01263f
C82 VPWR.n14 VNB 0.03565f
C83 VPWR.n15 VNB 0.00961f
C84 VPWR.n16 VNB 0.1698f
C85 VPWR.n17 VNB 0.07429f
C86 VPWR.t2 VNB 0.0676f
C87 VPWR.n18 VNB 0.04026f
C88 VPWR.t1 VNB 0.03978f
C89 VPWR.t3 VNB 0.04225f
C90 VPWR.n19 VNB 0.02211f
C91 VPWR.n20 VNB 0.02165f
C92 VPWR.t0 VNB 0.068f
C93 Y.n0 VNB 0.0482f
C94 Y.t0 VNB 0.05337f
C95 Y.n1 VNB 0.11368f
C96 Y.t1 VNB 0.08947f
C97 VGND.n0 VNB 0.00656f
C98 VGND.n1 VNB 0.02507f
C99 VGND.n2 VNB 0.00888f
C100 VGND.n3 VNB 0.02507f
C101 VGND.n4 VNB 0.00888f
C102 VGND.n5 VNB 0.02507f
C103 VGND.n6 VNB 0.00468f
C104 VGND.n7 VNB 0.03279f
C105 VGND.n8 VNB 0.27201f
C106 VGND.n9 VNB 0.03458f
C107 VGND.t4 VNB 0.03738f
C108 VGND.t0 VNB 0.03331f
C109 VGND.t3 VNB 0.0339f
C110 VGND.t1 VNB 0.03738f
C111 VGND.n10 VNB 0.03017f
C112 VGND.n11 VNB 0.01466f
C113 VGND.t2 VNB 0.03601f
C114 VGND.n12 VNB 0.0234f
C115 VGND.n13 VNB 0.01931f
.ends
