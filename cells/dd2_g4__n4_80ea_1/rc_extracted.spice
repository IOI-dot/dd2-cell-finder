* NGSPICE file created from dd2_g4__n4_80ea_1.ext - technology: sky130A

.subckt dd2_g4__n4_80ea_1 A B C D VGND VNB VPB VPWR Y
X0 a_389_47.t2 a_49_47.t3 a_518_47.t2 VNB.t3 sky130_fd_pr__nfet_01v8 ad=0.08775 pd=0.92 as=0.16087 ps=1.145 w=0.65 l=0.15 sa=2.84 sb=2.04
X1 VPWR.t2 B.t1 a_260_297.t0 VPB.t0 sky130_fd_pr__pfet_01v8_hvt ad=0.2475 pd=1.495 as=0.2475 ps=1.495 w=1 l=0.15 sa=1.55 sb=2.39
X2 VGND.t0 A.t0 a_731_47.t1 VNB.t5 sky130_fd_pr__nfet_01v8 ad=0.25675 pd=1.44 as=0.08775 ps=0.92 w=0.65 l=0.15 sa=3.68 sb=1.2
X3 a_260_297.t3 C.t1 VPWR.t4 VPB.t7 sky130_fd_pr__pfet_01v8_hvt ad=0.2475 pd=1.495 as=0.2475 ps=1.495 w=1 l=0.15 sa=0.905 sb=3.035
X4 VGND.t3 D.t0 a_49_47.t1 VNB.t6 sky130_fd_pr__nfet_01v8 ad=0.16087 pd=1.145 as=0.169 ps=1.82 w=0.65 l=0.15 sa=0.26 sb=4.62
X5 a_518_47.t3 A.t2 a_260_297.t2 VPB.t5 sky130_fd_pr__pfet_01v8_hvt ad=0.26 pd=2.52 as=0.135 ps=1.27 w=1 l=0.15 sa=3.68 sb=0.26
X6 a_389_47.t0 B.t0 a_260_47.t0 VNB.t0 sky130_fd_pr__nfet_01v8 ad=0.16087 pd=1.145 as=0.16087 ps=1.145 w=0.65 l=0.15 sa=1.55 sb=3.33
X7 Y.t0 a_518_47.t5 VGND.t1 VNB.t1 sky130_fd_pr__nfet_01v8 ad=0.169 pd=1.82 as=0.25675 ps=1.44 w=0.65 l=0.15 sa=4.62 sb=0.26
X8 VPWR.t3 D.t1 a_49_47.t0 VPB.t6 sky130_fd_pr__pfet_01v8_hvt ad=0.2475 pd=1.495 as=0.26 ps=2.52 w=1 l=0.15 sa=0.26 sb=3.68
X9 a_260_47.t1 C.t0 VGND.t2 VNB.t7 sky130_fd_pr__nfet_01v8 ad=0.16087 pd=1.145 as=0.16087 ps=1.145 w=0.65 l=0.15 sa=0.905 sb=3.975
X10 Y.t1 a_518_47.t6 VPWR.t1 VPB.t1 sky130_fd_pr__pfet_01v8_hvt ad=0.26 pd=2.52 as=0.26 ps=2.52 w=1 l=0.15 sa=0.26 sb=0.26
X11 a_260_297.t1 a_49_47.t4 a_518_47.t0 VPB.t2 sky130_fd_pr__pfet_01v8_hvt ad=0.135 pd=1.27 as=0.135 ps=1.27 w=1 l=0.15 sa=3.26 sb=0.68
X12 a_518_47.t4 A.t1 a_389_47.t3 VNB.t4 sky130_fd_pr__nfet_01v8 ad=0.16087 pd=1.145 as=0.16087 ps=1.145 w=0.65 l=0.15 sa=2.195 sb=2.685
X13 a_731_47.t0 a_49_47.t2 a_389_47.t1 VNB.t2 sky130_fd_pr__nfet_01v8 ad=0.08775 pd=0.92 as=0.08775 ps=0.92 w=0.65 l=0.15 sa=3.26 sb=1.62
X14 a_518_297.t1 A.t3 VPWR.t0 VPB.t4 sky130_fd_pr__pfet_01v8_hvt ad=0.2475 pd=1.495 as=0.2475 ps=1.495 w=1 l=0.15 sa=2.195 sb=1.745
X15 a_518_47.t1 a_49_47.t5 a_518_297.t0 VPB.t3 sky130_fd_pr__pfet_01v8_hvt ad=0.135 pd=1.27 as=0.2475 ps=1.495 w=1 l=0.15 sa=2.84 sb=1.1
R0 VGND VGND.n0 0.202353
R1 VGND.n0 VGND.n1 132.133
R2 VGND.n0 VGND.n2 133.107
R3 VGND.n2 VGND.t3 46.1543
R4 VGND.n2 VGND.t2 45.2313
R5 VGND.n1 VGND.t0 72.9236
R6 VGND.n1 VGND.t1 72.9236
R7 Y.n1 Y.n0 20.7374
R8 Y.n1 Y.t1 228.772
R9 Y Y.n1 3.29747
R10 Y Y.n0 1.64144
R11 Y.n0 Y.t0 133.386
R12 VPWR.n2 VPWR.n1 9.3005
R13 VPWR.n4 VPWR.n3 9.3005
R14 VPWR.n6 VPWR.n5 9.3005
R15 VPWR VPWR.n0 0.121778
R16 VPWR.n0 VPWR.n2 0.141672
R17 VPWR.n2 VPWR.n4 0.120292
R18 VPWR.n4 VPWR.n6 0.120292
R19 VPWR.n6 VPWR.n7 0.150048
R20 VPWR.n7 VPWR.t1 887.264
R21 VPWR.n0 VPWR.n9 23.8473
R22 VPWR.n9 VPWR.n1 18.4476
R23 VPWR.n1 VPWR.n3 34.6358
R24 VPWR.n3 VPWR.n5 34.6358
R25 VPWR.n5 VPWR.n11 9.41227
R26 VPWR.n11 VPWR.n7 32.8218
R27 VPWR.n11 VPWR.n10 607.212
R28 VPWR.n10 VPWR.t2 49.2505
R29 VPWR.n10 VPWR.t0 48.2655
R30 VPWR.n9 VPWR.n8 320.976
R31 VPWR.n8 VPWR.t3 49.2505
R32 VPWR.n8 VPWR.t4 48.2655
R33 A.n1 A.n0 152
R34 A A.n1 6.4005
R35 A.n3 A.n1 25.499
R36 A A.n3 0.376971
R37 A.n3 A.n2 158.024
R38 A.n2 A.t0 169.237
R39 A.n2 A.t2 241.536
R40 A.n0 A.t1 158.064
R41 A.n0 A.t3 230.363
R42 B B.n0 158.4
R43 B.n0 B.t0 158.064
R44 B.n0 B.t1 230.363
R45 C C.n0 158.4
R46 C.n0 C.t0 158.064
R47 C.n0 C.t1 230.363
R48 D D.n0 158.4
R49 D.n0 D.t0 158.064
R50 D.n0 D.t1 230.363
R51 VPB VPB.t6 257.478
R52 VPB.t6 VPB.t7 381.776
R53 VPB.t7 VPB.t0 381.776
R54 VPB.t0 VPB.t4 381.776
R55 VPB.t4 VPB.t3 381.776
R56 VPB.t3 VPB.t2 248.599
R57 VPB.t2 VPB.t5 248.599
R58 VPB.t5 VPB.t1 556.386
R59 VNB VNB.t6 1238.83
R60 VNB.t6 VNB.t7 1836.89
R61 VNB.t7 VNB.t0 1836.89
R62 VNB.t0 VNB.t4 1836.89
R63 VNB.t4 VNB.t3 1836.89
R64 VNB.t3 VNB.t2 1196.12
R65 VNB.t2 VNB.t5 1196.12
R66 VNB.t5 VNB.t1 2677.02
R67 a_731_47.t0 a_731_47.t1 49.8467
R68 a_389_47.n0 a_389_47.n1 356.733
R69 a_389_47.t0 a_389_47.n0 46.1543
R70 a_389_47.n0 a_389_47.t3 45.2313
R71 a_389_47.n1 a_389_47.t2 24.9236
R72 a_389_47.n1 a_389_47.t1 24.9236
R73 a_260_47.t0 a_260_47.t1 91.3851
R74 a_518_297.t0 a_518_297.t1 97.5155
R75 a_260_297.n0 a_260_297.t3 48.2655
R76 a_260_297.t0 a_260_297.n0 49.2505
R77 a_260_297.n0 a_260_297.n1 1056.19
R78 a_260_297.n1 a_260_297.t1 26.5955
R79 a_260_297.n1 a_260_297.t2 26.5955
R80 a_518_47.n0 a_518_47.n4 585
R81 a_518_47.n0 a_518_47.t1 26.5955
R82 a_518_47.t0 a_518_47.n0 26.5955
R83 a_518_47.n4 a_518_47.n2 50.824
R84 a_518_47.n4 a_518_47.n3 281.753
R85 a_518_47.n3 a_518_47.t4 45.2313
R86 a_518_47.n3 a_518_47.t2 46.1543
R87 a_518_47.n2 a_518_47.t3 228.773
R88 a_518_47.n2 a_518_47.n1 223.906
R89 a_518_47.n1 a_518_47.t5 169.237
R90 a_518_47.n1 a_518_47.t6 241.536
R91 a_49_47.t0 a_49_47.n2 241.286
R92 a_49_47.n2 a_49_47.t1 154.077
R93 a_49_47.n2 a_49_47.n1 381.668
R94 a_49_47.n1 a_49_47.n0 61.346
R95 a_49_47.n1 a_49_47.t5 212.081
R96 a_49_47.n1 a_49_47.t3 139.78
R97 a_49_47.n0 a_49_47.t4 212.081
R98 a_49_47.n0 a_49_47.t2 139.78
C0 VGND Y 0.05394f
C1 A VPB 0.07374f
C2 B VPB 0.03953f
C3 VPWR C 0.0219f
C4 A D 0
C5 VPB C 0.03953f
C6 VPWR VGND 0.04094f
C7 A B 0.03015f
C8 VGND VPB 0.01424f
C9 D C 0.02721f
C10 VPWR Y 0.05027f
C11 VGND D 0.01852f
C12 A C 0.00124f
C13 VPB Y 0.02103f
C14 B C 0.02721f
C15 A VGND 0.07317f
C16 B VGND 0.02219f
C17 D Y 0
C18 VPWR VPB 0.157f
C19 A Y 0.00784f
C20 B Y 0
C21 VGND C 0.03528f
C22 VPWR D 0.01737f
C23 C Y 0
C24 D VPB 0.04187f
C25 VPWR A 0.05729f
C26 VPWR B 0.01685f
C27 VGND VNB 0.12253f
C28 Y VNB 0f
C29 VPWR VNB 0f
C30 A VNB 0f
C31 B VNB 0.02243f
C32 C VNB 0.01922f
C33 D VNB 0.05452f
C34 VPB VNB 0.68399f
C35 a_49_47.t0 VNB 0.10703f
C36 a_49_47.n0 VNB 0.05445f
C37 a_49_47.n1 VNB 0.12653f
C38 a_49_47.n2 VNB 0.3334f
C39 a_49_47.t1 VNB 0.07345f
C40 a_518_47.t0 VNB 0.04096f
C41 a_518_47.n0 VNB 0.03741f
C42 a_518_47.n1 VNB 0.05282f
C43 a_518_47.n2 VNB 0.14766f
C44 a_518_47.t3 VNB 0.09753f
C45 a_518_47.t4 VNB 0.04286f
C46 a_518_47.t2 VNB 0.0381f
C47 a_518_47.n3 VNB 0.05849f
C48 a_518_47.n4 VNB 0.08137f
C49 a_518_47.t1 VNB 0.04096f
C50 a_260_297.t0 VNB 0.06263f
C51 a_260_297.n0 VNB 0.1891f
C52 a_260_297.t1 VNB 0.04167f
C53 a_260_297.t2 VNB 0.04861f
C54 a_260_297.n1 VNB 0.10159f
C55 a_260_297.t3 VNB 0.06292f
C56 a_518_297.t0 VNB 0.04699f
C57 a_518_297.t1 VNB 0.05356f
C58 a_260_47.t0 VNB 0.03843f
C59 a_260_47.t1 VNB 0.03915f
C60 a_389_47.t0 VNB 0.04142f
C61 a_389_47.n0 VNB 0.11116f
C62 a_389_47.t2 VNB 0.02756f
C63 a_389_47.t1 VNB 0.02756f
C64 a_389_47.n1 VNB 0.05709f
C65 a_389_47.t3 VNB 0.04252f
C66 a_731_47.t0 VNB 0.02626f
C67 a_731_47.t1 VNB 0.03178f
C68 VPB.t0 VNB 0.06085f
C69 VPB.t1 VNB 0.11698f
C70 VPB.t2 VNB 0.03962f
C71 VPB.t3 VNB 0.05023f
C72 VPB.t4 VNB 0.06085f
C73 VPB.t5 VNB 0.06415f
C74 VPB.t6 VNB 0.05094f
C75 VPB.t7 VNB 0.06085f
C76 D.n0 VNB 0.0723f
C77 C.n0 VNB 0.07798f
C78 B.n0 VNB 0.07515f
C79 A.n0 VNB 0.08064f
C80 A.n1 VNB 0.07537f
C81 A.n2 VNB 0.05897f
C82 A.n3 VNB 0.12076f
C83 VPWR.n0 VNB 0.03966f
C84 VPWR.n1 VNB 0.00872f
C85 VPWR.n2 VNB 0.03698f
C86 VPWR.n3 VNB 0.01138f
C87 VPWR.n4 VNB 0.03212f
C88 VPWR.n5 VNB 0.00723f
C89 VPWR.n6 VNB 0.04387f
C90 VPWR.n7 VNB 0.30278f
C91 VPWR.n8 VNB 0.03744f
C92 VPWR.t3 VNB 0.04385f
C93 VPWR.t4 VNB 0.0455f
C94 VPWR.n9 VNB 0.02748f
C95 VPWR.t2 VNB 0.04486f
C96 VPWR.t0 VNB 0.04664f
C97 VPWR.n10 VNB 0.03628f
C98 VPWR.n11 VNB 0.01963f
C99 VPWR.t1 VNB 0.05588f
C100 Y.n0 VNB 0.03522f
C101 Y.t0 VNB 0.04112f
C102 Y.n1 VNB 0.08307f
C103 Y.t1 VNB 0.06828f
C104 VGND.n0 VNB 0.39731f
C105 VGND.n1 VNB 0.03668f
C106 VGND.t0 VNB 0.03618f
C107 VGND.t1 VNB 0.03037f
C108 VGND.n2 VNB 0.02408f
C109 VGND.t3 VNB 0.02806f
C110 VGND.t2 VNB 0.02932f
.ends
