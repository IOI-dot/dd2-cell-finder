.subckt dd2_g4__n4_80ea_1 A B C D VGND VNB VPB VPWR Y
X0 _s1 D VGND VNB sky130_fd_pr__nfet_01v8 w=650000u l=150000u
X1 _s2 _s1 n1 VNB sky130_fd_pr__nfet_01v8 w=650000u l=150000u
X2 _s2 A n1 VNB sky130_fd_pr__nfet_01v8 w=650000u l=150000u
X3 n1 _s1 n2 VNB sky130_fd_pr__nfet_01v8 w=650000u l=150000u
X4 n2 A VGND VNB sky130_fd_pr__nfet_01v8 w=650000u l=150000u
X5 n1 B n3 VNB sky130_fd_pr__nfet_01v8 w=650000u l=150000u
X6 n3 C VGND VNB sky130_fd_pr__nfet_01v8 w=650000u l=150000u
X7 Y _s2 VGND VNB sky130_fd_pr__nfet_01v8 w=650000u l=150000u
X8 _s1 D VPWR VPB sky130_fd_pr__pfet_01v8_hvt w=1000000u l=150000u
X9 _s2 _s1 p1 VPB sky130_fd_pr__pfet_01v8_hvt w=1000000u l=150000u
X10 p1 A VPWR VPB sky130_fd_pr__pfet_01v8_hvt w=1000000u l=150000u
X11 _s2 _s1 p2 VPB sky130_fd_pr__pfet_01v8_hvt w=1000000u l=150000u
X12 _s2 A p2 VPB sky130_fd_pr__pfet_01v8_hvt w=1000000u l=150000u
X13 p2 B VPWR VPB sky130_fd_pr__pfet_01v8_hvt w=1000000u l=150000u
X14 p2 C VPWR VPB sky130_fd_pr__pfet_01v8_hvt w=1000000u l=150000u
X15 Y _s2 VPWR VPB sky130_fd_pr__pfet_01v8_hvt w=1000000u l=150000u
.ends
