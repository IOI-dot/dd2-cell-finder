* NGSPICE file created from dd2_t_nor3.ext - technology: sky130A

.subckt dd2_t_nor3 A B C VGND VNB VPB VPWR Y
X0 a_145_297.t1 C.t1 VPWR.t0 VPB.t2 sky130_fd_pr__pfet_01v8_hvt ad=0.175 pd=1.35 as=0.26 ps=2.52 w=1 l=0.15 sa=0.26 sb=1.26
X1 VGND.t1 B.t0 Y.t2 VNB.t0 sky130_fd_pr__nfet_01v8 ad=0.11375 pd=1 as=0.11375 ps=1 w=0.65 l=0.15 sa=0.76 sb=0.76
X2 Y.t0 A.t1 a_245_297.t1 VPB.t1 sky130_fd_pr__pfet_01v8_hvt ad=0.26 pd=2.52 as=0.175 ps=1.35 w=1 l=0.15 sa=1.26 sb=0.26
X3 Y.t3 C.t0 VGND.t2 VNB.t2 sky130_fd_pr__nfet_01v8 ad=0.11375 pd=1 as=0.169 ps=1.82 w=0.65 l=0.15 sa=0.26 sb=1.26
X4 a_245_297.t0 B.t1 a_145_297.t0 VPB.t0 sky130_fd_pr__pfet_01v8_hvt ad=0.175 pd=1.35 as=0.175 ps=1.35 w=1 l=0.15 sa=0.76 sb=0.76
X5 Y.t1 A.t0 VGND.t0 VNB.t1 sky130_fd_pr__nfet_01v8 ad=0.169 pd=1.82 as=0.11375 ps=1 w=0.65 l=0.15 sa=1.26 sb=0.26
R0 VGND VGND.n0 0.463182
R1 VGND.n0 VGND.n1 219.464
R2 VGND.n0 VGND.t2 172.694
R3 VGND.n1 VGND.t1 32.3082
R4 VGND.n1 VGND.t0 32.3082
R5 Y Y.n5 20.4005
R6 Y.n0 Y.n1 185
R7 Y.n1 Y.n2 185
R8 Y Y.n0 6.4005
R9 Y.n0 Y.n5 12.8005
R10 Y.n5 Y.n2 12.8005
R11 Y.n2 Y.n4 65.8829
R12 Y.n4 Y.t0 293.505
R13 Y Y.n3 9.74966
R14 Y.n4 Y.n3 6.23053
R15 Y.n3 Y.t1 128.523
R16 Y.n1 Y.t3 32.3082
R17 Y.n1 Y.t2 32.3082
R18 VPWR VPWR.t0 270.406
R19 A A.n0 158.4
R20 A.n0 A.t0 169.237
R21 A.n0 A.t1 241.536
R22 B B.n0 158.4
R23 B.n0 B.t0 169.237
R24 B.n0 B.t1 241.536
R25 C C.n0 158.4
R26 C.n0 C.t0 169.237
R27 C.n0 C.t1 241.536
R28 VPB VPB.t2 298.911
R29 VPB.t2 VPB.t0 295.95
R30 VPB.t0 VPB.t1 295.95
R31 VNB VNB.t2 1438.19
R32 VNB.t2 VNB.t0 1423.95
R33 VNB.t0 VNB.t1 1423.95
R34 a_245_297.t0 a_245_297.t1 68.9505
R35 a_145_297.t0 a_145_297.t1 68.9505
C0 VGND C 0.03072f
C1 Y C 0.00854f
C2 VPB A 0.03531f
C3 VPB B 0.03109f
C4 B C 0.03085f
C5 VPB VPWR 0.09501f
C6 VPWR C 0.0322f
C7 VGND Y 0.12936f
C8 VGND A 0.01548f
C9 A Y 0.0517f
C10 VGND B 0.01725f
C11 B Y 0.03325f
C12 VGND VPWR 0.02832f
C13 B A 0.03085f
C14 VPWR Y 0.0497f
C15 VPB C 0.03487f
C16 VPWR A 0.01683f
C17 B VPWR 0.02136f
C18 VPB VGND 0.0118f
C19 VPB Y 0.02176f
C20 VGND VNB 0.28687f
C21 Y VNB 0f
C22 VPWR VNB 0.46028f
C23 A VNB 0.05133f
C24 B VNB 0.02209f
C25 C VNB 0.06292f
C26 VPB VNB 0.3871f
C27 a_145_297.t0 VNB 0.04529f
C28 a_145_297.t1 VNB 0.04038f
C29 a_245_297.t0 VNB 0.04527f
C30 a_245_297.t1 VNB 0.04283f
C31 VPB.t0 VNB 0.04288f
C32 VPB.t1 VNB 0.09348f
C33 VPB.t2 VNB 0.04309f
C34 C.n0 VNB 0.04503f
C35 B.n0 VNB 0.05494f
C36 A.n0 VNB 0.05002f
C37 VPWR.t0 VNB 0.06272f
C38 Y.n0 VNB 0.00422f
C39 Y.n1 VNB 0.02215f
C40 Y.t3 VNB 0.02718f
C41 Y.t2 VNB 0.03073f
C42 Y.n2 VNB 0.01986f
C43 Y.n3 VNB 0.00581f
C44 Y.t1 VNB 0.04358f
C45 Y.n4 VNB 0.10996f
C46 Y.t0 VNB 0.09132f
C47 Y.n5 VNB 0.01755f
C48 VGND.n0 VNB 0.0723f
C49 VGND.t1 VNB 0.0261f
C50 VGND.t0 VNB 0.02434f
C51 VGND.n1 VNB 0.01459f
C52 VGND.t2 VNB 0.03586f
.ends
