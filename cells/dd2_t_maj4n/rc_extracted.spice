* NGSPICE file created from dd2_t_maj4n.ext - technology: sky130A

.subckt dd2_t_maj4n A B C D VGND VNB VPB VPWR Y
X0 a_110_297.t3 D.t3 VPWR.t1 VPB.t4 sky130_fd_pr__pfet_01v8_hvt ad=0.135 pd=1.27 as=0.26 ps=2.52 w=1 l=0.15 sa=0.26 sb=2.99
X1 a_572_47.t1 A.t0 a_194_47.t2 VNB.t3 sky130_fd_pr__nfet_01v8 ad=0.08775 pd=0.92 as=0.10725 ps=0.98 w=0.65 l=0.15 sa=2.57 sb=0.68
X2 a_194_47.t1 C.t0 Y.t2 VNB.t1 sky130_fd_pr__nfet_01v8 ad=0.10725 pd=0.98 as=0.19987 ps=1.265 w=0.65 l=0.15 sa=2.09 sb=1.16
X3 VGND.t0 B.t0 a_572_47.t0 VNB.t2 sky130_fd_pr__nfet_01v8 ad=0.169 pd=1.82 as=0.08775 ps=0.92 w=0.65 l=0.15 sa=2.99 sb=0.26
X4 a_323_297.t1 D.t2 VPWR.t2 VPB.t5 sky130_fd_pr__pfet_01v8_hvt ad=0.3075 pd=1.615 as=0.2475 ps=1.495 w=1 l=0.15 sa=1.325 sb=1.925
X5 a_194_47.t0 C.t1 a_110_47.t0 VNB.t0 sky130_fd_pr__nfet_01v8 ad=0.16087 pd=1.145 as=0.08775 ps=0.92 w=0.65 l=0.15 sa=0.68 sb=2.57
X6 a_110_47.t1 D.t1 VGND.t1 VNB.t4 sky130_fd_pr__nfet_01v8 ad=0.08775 pd=0.92 as=0.169 ps=1.82 w=0.65 l=0.15 sa=0.26 sb=2.99
X7 Y.t0 B.t1 a_110_297.t1 VPB.t2 sky130_fd_pr__pfet_01v8_hvt ad=0.26 pd=2.52 as=0.135 ps=1.27 w=1 l=0.15 sa=2.99 sb=0.26
X8 Y.t4 C.t2 a_323_297.t0 VPB.t1 sky130_fd_pr__pfet_01v8_hvt ad=0.165 pd=1.33 as=0.3075 ps=1.615 w=1 l=0.15 sa=2.09 sb=1.16
X9 a_110_297.t2 A.t1 Y.t1 VPB.t3 sky130_fd_pr__pfet_01v8_hvt ad=0.135 pd=1.27 as=0.165 ps=1.33 w=1 l=0.15 sa=2.57 sb=0.68
X10 VPWR.t0 C.t3 a_110_297.t0 VPB.t0 sky130_fd_pr__pfet_01v8_hvt ad=0.2475 pd=1.495 as=0.135 ps=1.27 w=1 l=0.15 sa=0.68 sb=2.57
X11 Y.t3 D.t0 a_194_47.t3 VNB.t5 sky130_fd_pr__nfet_01v8 ad=0.19987 pd=1.265 as=0.16087 ps=1.145 w=0.65 l=0.15 sa=1.325 sb=1.925
R0 VGND VGND.n0 0.0571008
R1 VGND.n0 VGND.t0 300.209
R2 VGND.n0 VGND.t1 299.435
R3 Y.n1 Y.n0 185
R4 Y Y.n1 6.4005
R5 Y.n4 Y.n1 143.06
R6 Y.n3 Y.n2 585
R7 Y Y.n3 6.4005
R8 Y.n3 Y.n4 39.9064
R9 Y.n4 Y.t0 241.948
R10 Y.n2 Y.t4 32.5055
R11 Y.n2 Y.t1 32.5055
R12 Y.n0 Y.t3 57.2313
R13 Y.n0 Y.t2 56.3082
R14 VPWR VPWR.n0 0.336238
R15 VPWR.n0 VPWR.n1 616.49
R16 VPWR.n1 VPWR.t0 48.2655
R17 VPWR.n1 VPWR.t2 49.2505
R18 VPWR.n0 VPWR.t1 266.339
R19 B B.n0 155.298
R20 B.n0 B.t0 158.064
R21 B.n0 B.t1 230.363
R22 A A.n0 155.298
R23 A.n0 A.t0 169.237
R24 A.n0 A.t1 241.536
R25 C.n1 C.n0 152
R26 C C.n1 6.4005
R27 C.n3 C.n2 152
R28 C C.n4 3.53153
R29 C.n4 C.n3 0.22119
R30 C.n3 C.n1 120.978
R31 C C.n4 6.8005
R32 C.n2 C.t0 169.237
R33 C.n2 C.t2 241.536
R34 C.n0 C.t1 158.064
R35 C.n0 C.t3 230.363
R36 D.n1 D.n0 152
R37 D D.n1 6.4005
R38 D.n3 D.n2 152
R39 D D.n1 120.847
R40 D D.n3 6.4005
R41 D D.n3 6.77697
R42 D.n2 D.t0 158.064
R43 D.n2 D.t2 230.363
R44 D D.n1 6.77697
R45 D.n0 D.t1 169.237
R46 D.n0 D.t3 241.536
R47 VPB VPB.t4 195.327
R48 VPB.t4 VPB.t0 248.599
R49 VPB.t0 VPB.t5 381.776
R50 VPB.t5 VPB.t1 452.805
R51 VPB.t1 VPB.t3 284.113
R52 VPB.t3 VPB.t2 248.599
R53 VNB VNB.t4 939.807
R54 VNB.t4 VNB.t0 1196.12
R55 VNB.t0 VNB.t5 1836.89
R56 VNB.t5 VNB.t1 2178.64
R57 VNB.t1 VNB.t3 1366.99
R58 VNB.t3 VNB.t2 1196.12
R59 a_572_47.t0 a_572_47.t1 49.8467
R60 a_194_47.t0 a_194_47.n0 45.2313
R61 a_194_47.n0 a_194_47.t3 46.1543
R62 a_194_47.n0 a_194_47.n1 470.142
R63 a_194_47.n1 a_194_47.t1 30.462
R64 a_194_47.n1 a_194_47.t2 30.462
R65 a_110_47.t0 a_110_47.t1 49.8467
R66 a_323_297.t0 a_323_297.t1 121.156
R67 a_110_297.n0 a_110_297.t3 26.5955
R68 a_110_297.t0 a_110_297.n0 26.5955
R69 a_110_297.n0 a_110_297.n1 955.244
R70 a_110_297.n1 a_110_297.t2 26.5955
R71 a_110_297.n1 a_110_297.t1 26.5955
C0 VGND B 0.02553f
C1 VGND C 0.02717f
C2 A VPB 0.0261f
C3 VPWR VPB 0.0991f
C4 D VPB 0.07176f
C5 VPWR A 0.00968f
C6 D A 0
C7 Y VPB 0.01766f
C8 D VPWR 0.04508f
C9 Y A 0.05436f
C10 B VPB 0.03721f
C11 VGND VPB 0.00882f
C12 C VPB 0.07729f
C13 Y VPWR 0.04382f
C14 B A 0.02548f
C15 Y D 0.01757f
C16 VGND A 0.01355f
C17 A C 0.03744f
C18 B VPWR 0.01221f
C19 VGND VPWR 0.04309f
C20 VGND D 0.05301f
C21 VPWR C 0.03947f
C22 D C 0.16113f
C23 Y B 0.05594f
C24 VGND Y 0.03645f
C25 Y C 0.03377f
C26 VGND VNB 0.14551f
C27 Y VNB 0f
C28 VPWR VNB 0.34268f
C29 B VNB 0.06497f
C30 A VNB 0.01905f
C31 C VNB 0f
C32 D VNB 0.04617f
C33 VPB VNB 0.52038f
C34 a_110_297.t0 VNB 0.05065f
C35 a_110_297.n0 VNB 0.2217f
C36 a_110_297.t2 VNB 0.05127f
C37 a_110_297.t1 VNB 0.04511f
C38 a_110_297.n1 VNB 0.10935f
C39 a_110_297.t3 VNB 0.04713f
C40 a_323_297.t0 VNB 0.05735f
C41 a_323_297.t1 VNB 0.05313f
C42 a_110_47.t0 VNB 0.02927f
C43 a_110_47.t1 VNB 0.02676f
C44 a_194_47.t0 VNB 0.04231f
C45 a_194_47.n0 VNB 0.08252f
C46 a_194_47.t1 VNB 0.03551f
C47 a_194_47.t2 VNB 0.03569f
C48 a_194_47.n1 VNB 0.06786f
C49 a_194_47.t3 VNB 0.03998f
C50 a_572_47.t0 VNB 0.02491f
C51 a_572_47.t1 VNB 0.0294f
C52 VPB.t0 VNB 0.04552f
C53 VPB.t1 VNB 0.05321f
C54 VPB.t2 VNB 0.0748f
C55 VPB.t3 VNB 0.03847f
C56 VPB.t4 VNB 0.03206f
C57 VPB.t5 VNB 0.06026f
C58 D.n0 VNB 0.04997f
C59 D.n1 VNB 0.06665f
C60 D.n2 VNB 0.06892f
C61 D.n3 VNB 0.01847f
C62 C.n0 VNB 0.07969f
C63 C.n1 VNB 0.05991f
C64 C.n2 VNB 0.05777f
C65 C.n3 VNB 0.06907f
C66 C.n4 VNB 0.01236f
C67 A.n0 VNB 0.05859f
C68 B.n0 VNB 0.06443f
C69 VPWR.n0 VNB 0.12084f
C70 VPWR.t1 VNB 0.06488f
C71 VPWR.t0 VNB 0.0464f
C72 VPWR.t2 VNB 0.04292f
C73 VPWR.n1 VNB 0.03695f
C74 Y.t3 VNB 0.0393f
C75 Y.t2 VNB 0.04204f
C76 Y.n0 VNB 0.0427f
C77 Y.n1 VNB 0.03726f
C78 Y.t4 VNB 0.04648f
C79 Y.t1 VNB 0.04672f
C80 Y.n2 VNB 0.03525f
C81 Y.n3 VNB 0.01117f
C82 Y.t0 VNB 0.07921f
C83 Y.n4 VNB 0.11155f
C84 VGND.n0 VNB 0.2784f
C85 VGND.t0 VNB 0.036f
C86 VGND.t1 VNB 0.03711f
.ends
