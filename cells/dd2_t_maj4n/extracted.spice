* NGSPICE file created from dd2_t_maj4n.ext - technology: sky130A

.subckt dd2_t_maj4n A B C D VGND VNB VPB VPWR Y
X0 a_110_297# D VPWR VPB sky130_fd_pr__pfet_01v8_hvt ad=0.135 pd=1.27 as=0.26 ps=2.52 w=1 l=0.15
X1 a_572_47# A a_194_47# VNB sky130_fd_pr__nfet_01v8 ad=0.08775 pd=0.92 as=0.10725 ps=0.98 w=0.65 l=0.15
X2 a_194_47# C Y VNB sky130_fd_pr__nfet_01v8 ad=0.10725 pd=0.98 as=0.19987 ps=1.265 w=0.65 l=0.15
X3 VGND B a_572_47# VNB sky130_fd_pr__nfet_01v8 ad=0.169 pd=1.82 as=0.08775 ps=0.92 w=0.65 l=0.15
X4 a_323_297# D VPWR VPB sky130_fd_pr__pfet_01v8_hvt ad=0.3075 pd=1.615 as=0.2475 ps=1.495 w=1 l=0.15
X5 a_194_47# C a_110_47# VNB sky130_fd_pr__nfet_01v8 ad=0.16087 pd=1.145 as=0.08775 ps=0.92 w=0.65 l=0.15
X6 a_110_47# D VGND VNB sky130_fd_pr__nfet_01v8 ad=0.08775 pd=0.92 as=0.169 ps=1.82 w=0.65 l=0.15
X7 Y B a_110_297# VPB sky130_fd_pr__pfet_01v8_hvt ad=0.26 pd=2.52 as=0.135 ps=1.27 w=1 l=0.15
X8 Y C a_323_297# VPB sky130_fd_pr__pfet_01v8_hvt ad=0.165 pd=1.33 as=0.3075 ps=1.615 w=1 l=0.15
X9 a_110_297# A Y VPB sky130_fd_pr__pfet_01v8_hvt ad=0.135 pd=1.27 as=0.165 ps=1.33 w=1 l=0.15
X10 VPWR C a_110_297# VPB sky130_fd_pr__pfet_01v8_hvt ad=0.2475 pd=1.495 as=0.135 ps=1.27 w=1 l=0.15
X11 Y D a_194_47# VNB sky130_fd_pr__nfet_01v8 ad=0.19987 pd=1.265 as=0.16087 ps=1.145 w=0.65 l=0.15
.ends
