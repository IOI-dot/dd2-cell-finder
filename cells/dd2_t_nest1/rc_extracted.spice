* NGSPICE file created from dd2_t_nest1.ext - technology: sky130A

.subckt dd2_t_nest1 A B C D VGND VNB VPB VPWR Y
X0 a_249_297.t0 C.t1 VPWR.t0 VPB.t0 sky130_fd_pr__pfet_01v8_hvt ad=0.26 pd=2.52 as=0.135 ps=1.27 w=1 l=0.15 sa=1.68 sb=0.26
X1 VGND.t0 B.t0 a_149_47.t2 VNB.t2 sky130_fd_pr__nfet_01v8 ad=0.11375 pd=1 as=0.11375 ps=1 w=0.65 l=0.15 sa=0.76 sb=1.18
X2 VPWR.t1 D.t1 a_249_297.t2 VPB.t3 sky130_fd_pr__pfet_01v8_hvt ad=0.135 pd=1.27 as=0.175 ps=1.35 w=1 l=0.15 sa=1.26 sb=0.68
X3 a_149_47.t1 A.t0 Y.t1 VNB.t1 sky130_fd_pr__nfet_01v8 ad=0.11375 pd=1 as=0.169 ps=1.82 w=0.65 l=0.15 sa=0.26 sb=1.68
X4 a_249_297.t1 B.t1 Y.t0 VPB.t2 sky130_fd_pr__pfet_01v8_hvt ad=0.175 pd=1.35 as=0.175 ps=1.35 w=1 l=0.15 sa=0.76 sb=1.18
X5 a_149_47.t0 C.t0 a_349_47.t0 VNB.t0 sky130_fd_pr__nfet_01v8 ad=0.169 pd=1.82 as=0.08775 ps=0.92 w=0.65 l=0.15 sa=1.68 sb=0.26
X6 Y.t2 A.t1 VPWR.t2 VPB.t1 sky130_fd_pr__pfet_01v8_hvt ad=0.175 pd=1.35 as=0.26 ps=2.52 w=1 l=0.15 sa=0.26 sb=1.68
X7 a_349_47.t1 D.t0 VGND.t1 VNB.t3 sky130_fd_pr__nfet_01v8 ad=0.08775 pd=0.92 as=0.11375 ps=1 w=0.65 l=0.15 sa=1.26 sb=0.68
R0 VGND VGND.n0 219.782
R1 VGND.n0 VGND.t0 32.3082
R2 VGND.n0 VGND.t1 32.3082
R3 Y Y.n1 6.28466
R4 Y.n0 Y.n2 193.627
R5 Y.n0 Y.n1 131.556
R6 Y Y.n0 7.52007
R7 Y.n2 Y.t2 34.4755
R8 Y.n2 Y.t0 34.4755
R9 Y.n1 Y.t1 129.632
R10 VPWR VPWR.n0 0.164506
R11 VPWR.n0 VPWR.n1 619.754
R12 VPWR.n1 VPWR.t1 26.5955
R13 VPWR.n1 VPWR.t0 26.5955
R14 VPWR.n0 VPWR.t2 888.962
R15 C C.n0 158.4
R16 C.n0 C.t0 169.237
R17 C.n0 C.t1 241.536
R18 D D.n0 158.4
R19 D.n0 D.t0 169.237
R20 D.n0 D.t1 241.536
R21 B B.n0 158.4
R22 B.n0 B.t0 169.237
R23 B.n0 B.t1 241.536
R24 A A.n0 158.4
R25 A.n0 A.t0 169.237
R26 A.n0 A.t1 241.536
R27 VPB VPB.t1 310.748
R28 VPB.t1 VPB.t2 295.95
R29 VPB.t2 VPB.t3 295.95
R30 VPB.t3 VPB.t0 248.599
R31 VNB VNB.t1 1495.15
R32 VNB.t1 VNB.t2 1423.95
R33 VNB.t2 VNB.t3 1423.95
R34 VNB.t3 VNB.t0 1196.12
R35 a_349_47.t0 a_349_47.t1 49.8467
R36 a_149_47.t0 a_149_47.n0 442.301
R37 a_149_47.n0 a_149_47.t1 32.3082
R38 a_149_47.n0 a_149_47.t2 32.3082
R39 a_249_297.t0 a_249_297.n0 465.906
R40 a_249_297.n0 a_249_297.t1 34.4755
R41 a_249_297.n0 a_249_297.t2 34.4755
C0 VGND VPWR 0.03062f
C1 D VPWR 0.01645f
C2 VPB VPWR 0.08816f
C3 Y VPWR 0.07685f
C4 VGND B 0.0165f
C5 D B 0.03085f
C6 B VPB 0.03007f
C7 Y B 0.01531f
C8 VGND D 0.01634f
C9 VGND VPB 0.01104f
C10 D VPB 0.02778f
C11 VGND Y 0.04506f
C12 D Y 0
C13 Y VPB 0.02258f
C14 VPWR A 0.01813f
C15 VPWR C 0.01494f
C16 B A 0.03085f
C17 VGND A 0.0154f
C18 VPB A 0.03355f
C19 VGND C 0.01305f
C20 D C 0.03192f
C21 Y A 0.05245f
C22 VPB C 0.03194f
C23 Y C 0
C24 B VPWR 0.01692f
C25 VGND VNB 0.51403f
C26 Y VNB 0f
C27 VPWR VNB 0.06676f
C28 C VNB 0.05863f
C29 D VNB 0.01993f
C30 B VNB 0.02049f
C31 A VNB 0.05189f
C32 VPB VNB 0.44232f
C33 a_249_297.t0 VNB 0.12901f
C34 a_249_297.n0 VNB 0.10029f
C35 a_249_297.t1 VNB 0.04491f
C36 a_249_297.t2 VNB 0.04522f
C37 a_149_47.t0 VNB 0.13542f
C38 a_149_47.t1 VNB 0.0333f
C39 a_149_47.t2 VNB 0.03567f
C40 a_149_47.n0 VNB 0.08505f
C41 a_349_47.t0 VNB 0.02677f
C42 a_349_47.t1 VNB 0.03028f
C43 VPB.t0 VNB 0.08936f
C44 VPB.t1 VNB 0.0428f
C45 VPB.t2 VNB 0.04176f
C46 VPB.t3 VNB 0.03842f
C47 A.n0 VNB 0.05078f
C48 B.n0 VNB 0.05741f
C49 D.n0 VNB 0.05804f
C50 C.n0 VNB 0.04824f
C51 VPWR.n0 VNB 0.18528f
C52 VPWR.t2 VNB 0.06138f
C53 VPWR.t1 VNB 0.03899f
C54 VPWR.t0 VNB 0.03414f
C55 VPWR.n1 VNB 0.02141f
C56 Y.n0 VNB 0.06458f
C57 Y.n1 VNB 0.06813f
C58 Y.t1 VNB 0.04497f
C59 Y.n2 VNB 0.03585f
C60 Y.t2 VNB 0.04291f
C61 Y.t0 VNB 0.04619f
C62 VGND.t0 VNB 0.0276f
C63 VGND.t1 VNB 0.02782f
C64 VGND.n0 VNB 0.01617f
.ends
