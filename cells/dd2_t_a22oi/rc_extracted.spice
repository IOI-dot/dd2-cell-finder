* NGSPICE file created from dd2_t_a22oi.ext - technology: sky130A

.subckt dd2_t_a22oi A B C D VGND VNB VPB VPWR Y
X0 a_59_297.t0 A.t1 Y.t1 VPB.t0 sky130_fd_pr__pfet_01v8_hvt ad=0.175 pd=1.35 as=0.175 ps=1.35 w=1 l=0.15 sa=0.76 sb=1.26
X1 a_341_47.t0 C.t0 Y.t0 VNB.t1 sky130_fd_pr__nfet_01v8 ad=0.11375 pd=1 as=0.11375 ps=1 w=0.65 l=0.15 sa=1.26 sb=0.76
X2 Y.t3 B.t1 a_59_297.t2 VPB.t2 sky130_fd_pr__pfet_01v8_hvt ad=0.175 pd=1.35 as=0.26 ps=2.52 w=1 l=0.15 sa=0.26 sb=1.76
X3 Y.t2 A.t0 a_141_47.t0 VNB.t0 sky130_fd_pr__nfet_01v8 ad=0.11375 pd=1 as=0.11375 ps=1 w=0.65 l=0.15 sa=0.76 sb=1.26
X4 a_59_297.t3 D.t1 VPWR.t0 VPB.t3 sky130_fd_pr__pfet_01v8_hvt ad=0.26 pd=2.52 as=0.175 ps=1.35 w=1 l=0.15 sa=1.76 sb=0.26
X5 a_141_47.t1 B.t0 VGND.t1 VNB.t2 sky130_fd_pr__nfet_01v8 ad=0.11375 pd=1 as=0.169 ps=1.82 w=0.65 l=0.15 sa=0.26 sb=1.76
X6 VPWR.t1 C.t1 a_59_297.t1 VPB.t1 sky130_fd_pr__pfet_01v8_hvt ad=0.175 pd=1.35 as=0.175 ps=1.35 w=1 l=0.15 sa=1.26 sb=0.76
X7 VGND.t0 D.t0 a_341_47.t1 VNB.t3 sky130_fd_pr__nfet_01v8 ad=0.169 pd=1.82 as=0.11375 ps=1 w=0.65 l=0.15 sa=1.76 sb=0.26
R0 VGND VGND.n0 0.101058
R1 VGND.n0 VGND.t0 303.503
R2 VGND.n0 VGND.t1 172.97
R3 VPWR VPWR.n0 619.918
R4 VPWR.n0 VPWR.t1 34.4755
R5 VPWR.n0 VPWR.t0 34.4755
R6 Y.n4 Y 6.8005
R7 Y.n1 Y.n0 185
R8 Y.n0 Y.n4 197.8
R9 Y Y.n4 6.4005
R10 Y Y.n1 6.4005
R11 Y.n3 Y.n2 585
R12 Y Y.n3 6.4005
R13 Y.n1 Y.n3 242.825
R14 Y Y.n3 6.77697
R15 Y.n2 Y.t3 34.4755
R16 Y.n2 Y.t1 34.4755
R17 Y.n0 Y.t2 32.3082
R18 Y.n0 Y.t0 32.3082
R19 D D.n0 158.4
R20 D.n0 D.t0 169.237
R21 D.n0 D.t1 241.536
R22 C C.n0 158.4
R23 C.n0 C.t0 169.237
R24 C.n0 C.t1 241.536
R25 A A.n0 158.4
R26 A.n0 A.t0 169.237
R27 A.n0 A.t1 241.536
R28 B B.n0 158.4
R29 B.n0 B.t0 169.237
R30 B.n0 B.t1 241.536
R31 VPB VPB.t2 287.072
R32 VPB.t2 VPB.t0 295.95
R33 VPB.t0 VPB.t1 295.95
R34 VPB.t1 VPB.t3 295.95
R35 VNB VNB.t2 1381.23
R36 VNB.t2 VNB.t0 1423.95
R37 VNB.t0 VNB.t1 1423.95
R38 VNB.t1 VNB.t3 1423.95
R39 a_341_47.t0 a_341_47.t1 64.6159
R40 a_141_47.t0 a_141_47.t1 64.6159
R41 a_59_297.n0 a_59_297.n1 292.5
R42 a_59_297.t0 a_59_297.n0 34.4755
R43 a_59_297.n0 a_59_297.t1 34.4755
R44 a_59_297.n1 a_59_297.t3 391.104
R45 a_59_297.n1 a_59_297.t2 296.207
C0 VPWR VPB 0.07865f
C1 VGND VPB 0.01213f
C2 Y D 0.05639f
C3 VPWR Y 0.02043f
C4 VPWR B 0.0094f
C5 VGND Y 0.08044f
C6 VGND B 0.03013f
C7 VPWR D 0.0145f
C8 C A 0.03085f
C9 VGND D 0.01659f
C10 VGND VPWR 0.02983f
C11 VPB A 0.0282f
C12 Y A 0.0289f
C13 B A 0.03085f
C14 VPWR A 0.00959f
C15 VGND A 0.02104f
C16 VPB C 0.0282f
C17 Y C 0.04787f
C18 D C 0.03085f
C19 Y VPB 0.01829f
C20 B VPB 0.03326f
C21 VPWR C 0.01538f
C22 VGND C 0.01406f
C23 D VPB 0.03234f
C24 Y B 0.00571f
C25 VGND VNB 0.20847f
C26 VPWR VNB 0.46709f
C27 Y VNB 0f
C28 D VNB 0.04915f
C29 C VNB 0.01933f
C30 A VNB 0.02493f
C31 B VNB 0.06352f
C32 VPB VNB 0.4451f
C33 a_59_297.t0 VNB 0.04518f
C34 a_59_297.n0 VNB 0.03686f
C35 a_59_297.t2 VNB 0.09197f
C36 a_59_297.n1 VNB 0.15818f
C37 a_59_297.t3 VNB 0.08747f
C38 a_59_297.t1 VNB 0.04759f
C39 a_141_47.t0 VNB 0.03281f
C40 a_141_47.t1 VNB 0.02931f
C41 a_341_47.t0 VNB 0.03305f
C42 a_341_47.t1 VNB 0.03104f
C43 VPB.t0 VNB 0.04022f
C44 VPB.t1 VNB 0.04022f
C45 VPB.t2 VNB 0.03961f
C46 VPB.t3 VNB 0.08606f
C47 B.n0 VNB 0.04437f
C48 A.n0 VNB 0.05418f
C49 C.n0 VNB 0.05905f
C50 D.n0 VNB 0.05344f
C51 Y.n0 VNB 0.03174f
C52 Y.t2 VNB 0.035f
C53 Y.t0 VNB 0.03674f
C54 Y.n1 VNB 0.0858f
C55 Y.t3 VNB 0.04598f
C56 Y.t1 VNB 0.05083f
C57 Y.n2 VNB 0.04805f
C58 Y.n3 VNB 0.09016f
C59 Y.n4 VNB 0.02644f
C60 VPWR.t1 VNB 0.04295f
C61 VPWR.t0 VNB 0.04017f
C62 VPWR.n0 VNB 0.02839f
C63 VGND.n0 VNB 0.16623f
C64 VGND.t0 VNB 0.03588f
C65 VGND.t1 VNB 0.03373f
.ends
