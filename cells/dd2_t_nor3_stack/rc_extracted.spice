* NGSPICE file created from dd2_t_nor3_stack.ext - technology: sky130A

.subckt dd2_t_nor3_stack A B C VGND VNB VPB VPWR Y
X0 a_121_297.t3 A.t3 Y.t5 VPB.t3 sky130_fd_pr__pfet_01v8_hvt ad=0.135 pd=1.27 as=0.26 ps=2.52 w=1 l=0.15 sa=0.26 sb=3.8
X1 a_409_297.t4 C.t2 VPWR.t1 VPB.t7 sky130_fd_pr__pfet_01v8_hvt ad=0.135 pd=1.27 as=0.135 ps=1.27 w=1 l=0.15 sa=2.96 sb=1.1
X2 VPWR.t2 C.t3 a_409_297.t3 VPB.t6 sky130_fd_pr__pfet_01v8_hvt ad=0.135 pd=1.27 as=0.135 ps=1.27 w=1 l=0.15 sa=3.38 sb=0.68
X3 a_121_297.t5 A.t1 Y.t2 VPB.t5 sky130_fd_pr__pfet_01v8_hvt ad=0.225 pd=1.45 as=0.135 ps=1.27 w=1 l=0.15 sa=0.68 sb=3.38
X4 a_409_297.t1 B.t1 a_121_297.t2 VPB.t2 sky130_fd_pr__pfet_01v8_hvt ad=0.135 pd=1.27 as=0.135 ps=1.27 w=1 l=0.15 sa=1.7 sb=2.36
X5 Y.t4 A.t2 a_121_297.t4 VPB.t4 sky130_fd_pr__pfet_01v8_hvt ad=0.135 pd=1.27 as=0.135 ps=1.27 w=1 l=0.15 sa=1.1 sb=2.96
X6 a_121_297.t1 B.t2 a_409_297.t0 VPB.t1 sky130_fd_pr__pfet_01v8_hvt ad=0.135 pd=1.27 as=0.135 ps=1.27 w=1 l=0.15 sa=2.12 sb=1.94
X7 Y.t3 A.t0 VGND.t2 VNB.t1 sky130_fd_pr__nfet_01v8 ad=0.41925 pd=1.94 as=0.169 ps=1.82 w=0.65 l=0.15 sa=0.26 sb=2.96
X8 a_409_297.t2 B.t3 a_121_297.t0 VPB.t0 sky130_fd_pr__pfet_01v8_hvt ad=0.135 pd=1.27 as=0.225 ps=1.45 w=1 l=0.15 sa=2.54 sb=1.52
X9 Y.t0 C.t0 VGND.t0 VNB.t2 sky130_fd_pr__nfet_01v8 ad=0.169 pd=1.82 as=0.36075 ps=1.76 w=0.65 l=0.15 sa=2.96 sb=0.26
X10 VGND.t1 B.t0 Y.t1 VNB.t0 sky130_fd_pr__nfet_01v8 ad=0.36075 pd=1.76 as=0.41925 ps=1.94 w=0.65 l=0.15 sa=1.7 sb=1.52
X11 VPWR.t0 C.t1 a_409_297.t5 VPB.t8 sky130_fd_pr__pfet_01v8_hvt ad=0.26 pd=2.52 as=0.135 ps=1.27 w=1 l=0.15 sa=3.8 sb=0.26
R0 VGND VGND.n0 0.0691863
R1 VGND.n0 VGND.n1 215.779
R2 VGND.n0 VGND.t2 171.252
R3 VGND.n1 VGND.t1 180
R4 VGND.n1 VGND.t0 24.9236
R5 VPWR VPWR.n0 1.27964
R6 VPWR.n0 VPWR.t0 268.286
R7 VPWR.n0 VPWR.n1 613.726
R8 VPWR.n1 VPWR.t2 26.5955
R9 VPWR.n1 VPWR.t1 26.5955
R10 Y.n5 Y.n0 185
R11 Y.n0 Y 194.892
R12 Y Y.n5 3.29747
R13 Y Y.n4 6.4005
R14 Y Y.n3 6.4005
R15 Y.n3 Y.n5 109.603
R16 Y Y.n4 2.25932
R17 Y.n4 Y.t0 271.647
R18 Y.n3 Y.t0 268.077
R19 Y.n5 Y.n2 56.0946
R20 Y.n2 Y.t5 302.846
R21 Y.n2 Y.n1 607.12
R22 Y.n1 Y.t4 26.5955
R23 Y.n1 Y.t2 26.5955
R24 Y.n0 Y.t3 196.615
R25 Y.n0 Y.t1 41.539
R26 C.n1 C.n2 61.346
R27 C.n0 C.n1 61.346
R28 C C.n0 164.061
R29 C.n2 C.t3 212.081
R30 C.n2 C.t0 139.78
R31 C.n1 C.t2 212.081
R32 C.n0 C.t1 212.081
R33 B B.n1 164.061
R34 B.n1 B.n0 61.346
R35 B.n1 B.t3 212.081
R36 B.n1 B.t0 139.78
R37 B.n0 B.t2 212.081
R38 B.n0 B.t1 273.425
R39 A.n1 A.n2 61.346
R40 A.n0 A.n1 61.346
R41 A A.n0 164.061
R42 A.n2 A.t3 212.081
R43 A.n2 A.t0 139.78
R44 A.n1 A.t2 212.081
R45 A.n0 A.t1 212.081
R46 VPB VPB.t3 227.882
R47 VPB.t3 VPB.t4 248.599
R48 VPB.t4 VPB.t5 248.599
R49 VPB.t5 VPB.t0 355.14
R50 VPB.t0 VPB.t1 248.599
R51 VPB.t1 VPB.t2 248.599
R52 VPB.t2 VPB.t6 248.599
R53 VPB.t6 VPB.t7 248.599
R54 VPB.t7 VPB.t8 248.599
R55 VNB VNB.t1 1096.44
R56 VNB.t1 VNB.t0 4100.97
R57 VNB.t0 VNB.t2 3588.35
R58 a_409_297.t4 a_409_297.n0 26.5955
R59 a_409_297.n0 a_409_297.t5 26.5955
R60 a_409_297.n0 a_409_297.n1 240.577
R61 a_409_297.n1 a_409_297.n2 202.178
R62 a_409_297.n1 a_409_297.n3 680.442
R63 a_409_297.n3 a_409_297.t2 26.5955
R64 a_409_297.n3 a_409_297.t0 26.5955
R65 a_409_297.n2 a_409_297.t1 26.5955
R66 a_409_297.n2 a_409_297.t3 26.5955
R67 a_121_297.n0 a_121_297.n2 354.824
R68 a_121_297.n0 a_121_297.t1 26.5955
R69 a_121_297.t2 a_121_297.n0 26.5955
R70 a_121_297.n2 a_121_297.n3 197.911
R71 a_121_297.n3 a_121_297.t5 44.3255
R72 a_121_297.n3 a_121_297.t0 44.3255
R73 a_121_297.n2 a_121_297.n1 354.824
R74 a_121_297.n1 a_121_297.t3 26.5955
R75 a_121_297.n1 a_121_297.t4 26.5955
C0 VPWR B 0.03473f
C1 VGND A 0.02975f
C2 Y A 0.10089f
C3 VPB A 0.09469f
C4 VGND C 0.03035f
C5 VGND Y 0.21698f
C6 VGND VPB 0.01187f
C7 Y C 0.0231f
C8 B A 0.03016f
C9 C VPB 0.09246f
C10 VPWR A 0.03363f
C11 Y VPB 0.02115f
C12 VGND B 0.02169f
C13 VGND VPWR 0.05177f
C14 C B 0.02289f
C15 VPWR C 0.05951f
C16 Y B 0.03418f
C17 VPB B 0.09012f
C18 VPWR Y 0.04703f
C19 VPWR VPB 0.1162f
C20 VGND VNB 0.21199f
C21 VPWR VNB 0.3465f
C22 Y VNB 0f
C23 C VNB 0.06828f
C24 B VNB 0.02082f
C25 A VNB 0.03503f
C26 VPB VNB 0.60308f
C27 a_121_297.t2 VNB 0.04216f
C28 a_121_297.n0 VNB 0.03714f
C29 a_121_297.n1 VNB 0.03714f
C30 a_121_297.t3 VNB 0.03666f
C31 a_121_297.t4 VNB 0.03666f
C32 a_121_297.n2 VNB 0.15486f
C33 a_121_297.n3 VNB 0.05211f
C34 a_121_297.t5 VNB 0.04691f
C35 a_121_297.t0 VNB 0.04752f
C36 a_121_297.t1 VNB 0.03727f
C37 a_409_297.t4 VNB 0.03638f
C38 a_409_297.n0 VNB 0.05024f
C39 a_409_297.n1 VNB 0.21588f
C40 a_409_297.n2 VNB 0.03735f
C41 a_409_297.t1 VNB 0.04416f
C42 a_409_297.t3 VNB 0.03638f
C43 a_409_297.t2 VNB 0.03926f
C44 a_409_297.t0 VNB 0.03926f
C45 a_409_297.n3 VNB 0.0409f
C46 a_409_297.t5 VNB 0.03638f
C47 VPB.t0 VNB 0.04627f
C48 VPB.t1 VNB 0.0381f
C49 VPB.t2 VNB 0.0381f
C50 VPB.t3 VNB 0.03651f
C51 VPB.t4 VNB 0.0381f
C52 VPB.t5 VNB 0.04627f
C53 VPB.t6 VNB 0.0381f
C54 VPB.t7 VNB 0.0381f
C55 VPB.t8 VNB 0.08437f
C56 A.n0 VNB 0.05352f
C57 A.n1 VNB 0.0556f
C58 A.n2 VNB 0.05207f
C59 B.n0 VNB 0.09104f
C60 B.n1 VNB 0.06498f
C61 C.n0 VNB 0.04782f
C62 C.n1 VNB 0.04967f
C63 C.n2 VNB 0.04652f
C64 Y.n0 VNB 0.08594f
C65 Y.t3 VNB 0.08526f
C66 Y.t1 VNB 0.0302f
C67 Y.t4 VNB 0.035f
C68 Y.t2 VNB 0.035f
C69 Y.n1 VNB 0.02798f
C70 Y.n2 VNB 0.11323f
C71 Y.t5 VNB 0.09029f
C72 Y.t0 VNB 0.04058f
C73 Y.n3 VNB 0.03532f
C74 Y.n4 VNB 0.03478f
C75 Y.n5 VNB 0.04957f
C76 VPWR.n0 VNB 0.24311f
C77 VPWR.t2 VNB 0.02956f
C78 VPWR.t1 VNB 0.02956f
C79 VPWR.n1 VNB 0.0217f
C80 VPWR.t0 VNB 0.06199f
C81 VGND.n0 VNB 0.27536f
C82 VGND.t1 VNB 0.04499f
C83 VGND.t0 VNB 0.01743f
C84 VGND.n1 VNB 0.03547f
C85 VGND.t2 VNB 0.03111f
.ends
