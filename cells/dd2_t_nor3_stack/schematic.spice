.subckt dd2_t_nor3_stack A B C VGND VNB VPB VPWR Y
X0 Y A VGND VNB sky130_fd_pr__nfet_01v8 w=650000u l=150000u
X1 Y B VGND VNB sky130_fd_pr__nfet_01v8 w=650000u l=150000u
X2 Y C VGND VNB sky130_fd_pr__nfet_01v8 w=650000u l=150000u
X3 Y A p1 VPB sky130_fd_pr__pfet_01v8_hvt w=1000000u l=150000u
X4 Y A p1 VPB sky130_fd_pr__pfet_01v8_hvt w=1000000u l=150000u
X5 Y A p1 VPB sky130_fd_pr__pfet_01v8_hvt w=1000000u l=150000u
X6 p1 B p2 VPB sky130_fd_pr__pfet_01v8_hvt w=1000000u l=150000u
X7 p1 B p2 VPB sky130_fd_pr__pfet_01v8_hvt w=1000000u l=150000u
X8 p1 B p2 VPB sky130_fd_pr__pfet_01v8_hvt w=1000000u l=150000u
X9 p2 C VPWR VPB sky130_fd_pr__pfet_01v8_hvt w=1000000u l=150000u
X10 p2 C VPWR VPB sky130_fd_pr__pfet_01v8_hvt w=1000000u l=150000u
X11 p2 C VPWR VPB sky130_fd_pr__pfet_01v8_hvt w=1000000u l=150000u
.ends
