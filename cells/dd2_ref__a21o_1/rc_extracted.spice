* NGSPICE file created from dd2_ref__a21o_1.ext - technology: sky130A

.subckt dd2_ref__a21o_1 A1 A2 B1 VGND VNB VPB VPWR X
X0 VGND.t0 B1.t0 a_243_47.t2 VNB.t3 sky130_fd_pr__nfet_01v8 ad=0.25675 pd=1.44 as=0.11375 ps=1 w=0.65 l=0.15 sa=1.26 sb=1.2
X1 a_243_47.t1 B1.t1 a_61_297.t2 VPB.t3 sky130_fd_pr__pfet_01v8_hvt ad=0.26 pd=2.52 as=0.175 ps=1.35 w=1 l=0.15 sa=1.26 sb=0.26
X2 a_243_47.t0 A1.t0 a_143_47.t1 VNB.t2 sky130_fd_pr__nfet_01v8 ad=0.11375 pd=1 as=0.11375 ps=1 w=0.65 l=0.15 sa=0.76 sb=1.7
X3 a_61_297.t1 A1.t1 VPWR.t1 VPB.t2 sky130_fd_pr__pfet_01v8_hvt ad=0.175 pd=1.35 as=0.175 ps=1.35 w=1 l=0.15 sa=0.76 sb=0.76
X4 X.t1 a_243_47.t4 VPWR.t0 VPB.t0 sky130_fd_pr__pfet_01v8_hvt ad=0.26 pd=2.52 as=0.26 ps=2.52 w=1 l=0.15 sa=0.26 sb=0.26
X5 X.t0 a_243_47.t3 VGND.t1 VNB.t0 sky130_fd_pr__nfet_01v8 ad=0.169 pd=1.82 as=0.25675 ps=1.44 w=0.65 l=0.15 sa=2.2 sb=0.26
X6 a_143_47.t0 A2.t0 VGND.t2 VNB.t1 sky130_fd_pr__nfet_01v8 ad=0.11375 pd=1 as=0.169 ps=1.82 w=0.65 l=0.15 sa=0.26 sb=2.2
X7 VPWR.t2 A2.t1 a_61_297.t0 VPB.t1 sky130_fd_pr__pfet_01v8_hvt ad=0.175 pd=1.35 as=0.26 ps=2.52 w=1 l=0.15 sa=0.26 sb=1.26
R0 VGND VGND.n0 0.11166
R1 VGND.n0 VGND.n1 215.941
R2 VGND.n0 VGND.t2 173.012
R3 VGND.n1 VGND.t0 72.9236
R4 VGND.n1 VGND.t1 72.9236
R5 X X.n0 6.4005
R6 X X.n1 6.4005
R7 X.n1 X.n0 157.365
R8 X.n1 X.t1 853.981
R9 X.n0 X.t0 268.077
R10 VPWR VPWR.n0 0.250574
R11 VPWR.n0 VPWR.t0 888.404
R12 VPWR.n0 VPWR.n1 619.494
R13 VPWR.n1 VPWR.t2 34.4755
R14 VPWR.n1 VPWR.t1 34.4755
R15 B1 B1.n0 158.4
R16 B1.n0 B1.t0 169.237
R17 B1.n0 B1.t1 241.536
R18 A1 A1.n0 158.4
R19 A1.n0 A1.t0 169.237
R20 A1.n0 A1.t1 241.536
R21 A2 A2.n0 158.4
R22 A2.n0 A2.t0 169.237
R23 A2.n0 A2.t1 241.536
R24 VPB VPB.t1 292.991
R25 VPB.t1 VPB.t2 295.95
R26 VPB.t2 VPB.t3 295.95
R27 VPB.t3 VPB.t0 556.386
R28 VNB VNB.t1 1409.71
R29 VNB.t1 VNB.t2 1423.95
R30 VNB.t2 VNB.t3 1423.95
R31 VNB.t3 VNB.t0 2677.02
R32 a_143_47.t0 a_143_47.t1 64.6159
R33 a_61_297.t0 a_61_297.n0 471.928
R34 a_61_297.n0 a_61_297.t1 34.4755
R35 a_61_297.n0 a_61_297.t2 34.4755
R36 a_243_47.t1 a_243_47.n1 416.69
R37 a_243_47.n1 a_243_47.n0 152
R38 a_243_47.n1 a_243_47.n2 188.75
R39 a_243_47.n2 a_243_47.t0 32.3082
R40 a_243_47.n2 a_243_47.t2 32.3082
R41 a_243_47.n0 a_243_47.t3 169.237
R42 a_243_47.n0 a_243_47.t4 241.536
C0 VPWR B1 0.01741f
C1 VGND VPB 0.01407f
C2 B1 VPB 0.03447f
C3 VPWR A2 0.01515f
C4 VPWR VPB 0.10222f
C5 A2 VPB 0.03291f
C6 VGND A1 0.02137f
C7 VGND X 0.04263f
C8 B1 A1 0.03085f
C9 B1 X 0
C10 VPWR A1 0.01766f
C11 A2 A1 0.03085f
C12 VPWR X 0.04374f
C13 A1 VPB 0.02921f
C14 X VPB 0.01973f
C15 B1 VGND 0.01608f
C16 VPWR VGND 0.03774f
C17 A2 VGND 0.03013f
C18 VGND VNB 0.19451f
C19 X VNB 0f
C20 VPWR VNB 0.0231f
C21 B1 VNB 0.03361f
C22 A1 VNB 0.02512f
C23 A2 VNB 0.06245f
C24 VPB VNB 0.48279f
C25 a_243_47.t1 VNB 0.10139f
C26 a_243_47.n0 VNB 0.0389f
C27 a_243_47.n1 VNB 0.14711f
C28 a_243_47.n2 VNB 0.06344f
C29 a_243_47.t0 VNB 0.03375f
C30 a_243_47.t2 VNB 0.03336f
C31 a_61_297.t0 VNB 0.12874f
C32 a_61_297.n0 VNB 0.1012f
C33 a_61_297.t1 VNB 0.04311f
C34 a_61_297.t2 VNB 0.04256f
C35 a_143_47.t0 VNB 0.02984f
C36 a_143_47.t1 VNB 0.0327f
C37 VPB.t0 VNB 0.11242f
C38 VPB.t1 VNB 0.04302f
C39 VPB.t2 VNB 0.04324f
C40 VPB.t3 VNB 0.06226f
C41 A2.n0 VNB 0.04592f
C42 A1.n0 VNB 0.0539f
C43 B1.n0 VNB 0.0528f
C44 VPWR.n0 VNB 0.24151f
C45 VPWR.t2 VNB 0.0359f
C46 VPWR.t1 VNB 0.03985f
C47 VPWR.n1 VNB 0.02712f
C48 VPWR.t0 VNB 0.05536f
C49 X.t0 VNB 0.04413f
C50 X.n0 VNB 0.04375f
C51 X.t1 VNB 0.06626f
C52 X.n1 VNB 0.04525f
C53 VGND.n0 VNB 0.17736f
C54 VGND.t0 VNB 0.03172f
C55 VGND.t1 VNB 0.02688f
C56 VGND.n1 VNB 0.02714f
C57 VGND.t2 VNB 0.03393f
.ends
