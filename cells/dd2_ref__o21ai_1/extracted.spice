* NGSPICE file created from dd2_ref__o21ai_1.ext - technology: sky130A

.subckt dd2_ref__o21ai_1 A1 A2 B1 VGND VNB VPB VPWR Y
X0 a_145_297# A1 VPWR VPB sky130_fd_pr__pfet_01v8_hvt ad=0.175 pd=1.35 as=0.26 ps=2.52 w=1 l=0.15
X1 a_63_47# A2 VGND VNB sky130_fd_pr__nfet_01v8 ad=0.11375 pd=1 as=0.11375 ps=1 w=0.65 l=0.15
X2 VPWR B1 Y VPB sky130_fd_pr__pfet_01v8_hvt ad=0.182 pd=1.92 as=0.14875 ps=1.35 w=0.7 l=0.15
X3 VGND A1 a_63_47# VNB sky130_fd_pr__nfet_01v8 ad=0.11375 pd=1 as=0.169 ps=1.82 w=0.65 l=0.15
X4 Y A2 a_145_297# VPB sky130_fd_pr__pfet_01v8_hvt ad=0.14875 pd=1.35 as=0.175 ps=1.35 w=1 l=0.15
X5 Y B1 a_63_47# VNB sky130_fd_pr__nfet_01v8 ad=0.169 pd=1.82 as=0.11375 ps=1 w=0.65 l=0.15
.ends
