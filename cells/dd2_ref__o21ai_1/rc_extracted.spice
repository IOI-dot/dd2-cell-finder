* NGSPICE file created from dd2_ref__o21ai_1.ext - technology: sky130A

.subckt dd2_ref__o21ai_1 A1 A2 B1 VGND VNB VPB VPWR Y
X0 a_145_297.t1 A1.t1 VPWR.t1 VPB.t2 sky130_fd_pr__pfet_01v8_hvt ad=0.175 pd=1.35 as=0.26 ps=2.52 w=1 l=0.15 sa=0.26 sb=1.26
X1 a_63_47.t0 A2.t0 VGND.t0 VNB.t0 sky130_fd_pr__nfet_01v8 ad=0.11375 pd=1 as=0.11375 ps=1 w=0.65 l=0.15 sa=0.76 sb=0.76
X2 VPWR.t0 B1.t1 Y.t2 VPB.t1 sky130_fd_pr__pfet_01v8_hvt ad=0.182 pd=1.92 as=0.14875 ps=1.35 w=0.7 l=0.15 sa=1.26 sb=0.26
X3 VGND.t1 A1.t0 a_63_47.t2 VNB.t2 sky130_fd_pr__nfet_01v8 ad=0.11375 pd=1 as=0.169 ps=1.82 w=0.65 l=0.15 sa=0.26 sb=1.26
X4 Y.t0 A2.t1 a_145_297.t0 VPB.t0 sky130_fd_pr__pfet_01v8_hvt ad=0.14875 pd=1.35 as=0.175 ps=1.35 w=1 l=0.15 sa=0.76 sb=0.76
X5 Y.t1 B1.t0 a_63_47.t1 VNB.t1 sky130_fd_pr__nfet_01v8 ad=0.169 pd=1.82 as=0.11375 ps=1 w=0.65 l=0.15 sa=1.26 sb=0.26
R0 VGND VGND.n0 219.802
R1 VGND.n0 VGND.t1 32.3082
R2 VGND.n0 VGND.t0 32.3082
R3 Y Y.n4 6.8005
R4 Y Y.n4 3.2005
R5 Y.n4 Y.n0 0.2005
R6 Y.n2 Y.n1 585
R7 Y.n0 Y.n2 140.248
R8 Y.n2 Y.n3 12.8005
R9 Y.n3 Y 6.4005
R10 Y Y.n1 591.4
R11 Y.n3 Y 6.8005
R12 Y.n1 Y.t0 46.953
R13 Y.n1 Y.t2 49.2505
R14 Y.n0 Y.t1 249.615
R15 VPWR VPWR.n0 0.163111
R16 VPWR.n0 VPWR.t0 775.649
R17 VPWR.n0 VPWR.t1 270.245
R18 B1 B1.n0 158.4
R19 B1.n0 B1.t0 169.237
R20 B1.n0 B1.t1 289.736
R21 A2 A2.n0 158.4
R22 A2.n0 A2.t0 169.237
R23 A2.n0 A2.t1 241.536
R24 A1 A1.n0 158.4
R25 A1.n0 A1.t0 169.237
R26 A1.n0 A1.t1 241.536
R27 VPB VPB.t2 298.911
R28 VPB.t2 VPB.t0 295.95
R29 VPB.t0 VPB.t1 295.95
R30 VNB VNB.t2 1438.19
R31 VNB.t2 VNB.t0 1423.95
R32 VNB.t0 VNB.t1 1423.95
R33 a_63_47.n0 a_63_47.t2 295.553
R34 a_63_47.t0 a_63_47.n0 32.3082
R35 a_63_47.n0 a_63_47.t1 32.3082
R36 a_145_297.t0 a_145_297.t1 68.9505
C0 VGND A1 0.01554f
C1 Y A1 0.00363f
C2 VPB B1 0.06342f
C3 VPB A2 0.03106f
C4 A2 A1 0.03085f
C5 VPB VPWR 0.10008f
C6 VPWR A1 0.03224f
C7 VGND Y 0.02877f
C8 VGND B1 0.01711f
C9 B1 Y 0.04406f
C10 VGND A2 0.01664f
C11 A2 Y 0.00874f
C12 VGND VPWR 0.02621f
C13 A2 B1 0.03085f
C14 VPWR Y 0.07856f
C15 VPB A1 0.03487f
C16 VPWR B1 0.0176f
C17 A2 VPWR 0.02192f
C18 VPB VGND 0.0125f
C19 VPB Y 0.02385f
C20 VGND VNB 0.4343f
C21 Y VNB 0f
C22 VPWR VNB 0.11039f
C23 B1 VNB 0.0503f
C24 A2 VNB 0.02175f
C25 A1 VNB 0.05945f
C26 VPB VNB 0.36563f
C27 a_145_297.t0 VNB 0.04656f
C28 a_145_297.t1 VNB 0.04257f
C29 a_63_47.t0 VNB 0.03301f
C30 a_63_47.n0 VNB 0.09192f
C31 a_63_47.t2 VNB 0.0996f
C32 a_63_47.t1 VNB 0.03476f
C33 VPB.t0 VNB 0.05001f
C34 VPB.t1 VNB 0.10903f
C35 VPB.t2 VNB 0.05026f
C36 A1.n0 VNB 0.0474f
C37 A2.n0 VNB 0.05546f
C38 B1.n0 VNB 0.06485f
C39 VPWR.n0 VNB 0.15373f
C40 VPWR.t1 VNB 0.06168f
C41 VPWR.t0 VNB 0.05159f
C42 Y.t1 VNB 0.05371f
C43 Y.n0 VNB 0.04612f
C44 Y.n1 VNB 0.03246f
C45 Y.t0 VNB 0.04502f
C46 Y.t2 VNB 0.04055f
C47 Y.n2 VNB 0.04187f
C48 Y.n3 VNB 0.01466f
C49 Y.n4 VNB 0.00719f
C50 VGND.t1 VNB 0.02392f
C51 VGND.t0 VNB 0.0268f
C52 VGND.n0 VNB 0.01585f
.ends
