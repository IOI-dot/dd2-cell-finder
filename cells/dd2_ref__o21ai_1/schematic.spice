.subckt dd2_ref__o21ai_1 A1 A2 B1 VGND VNB VPB VPWR Y
X0 Y B1 n1 VNB sky130_fd_pr__nfet_01v8 w=650000u l=150000u
X1 n1 A1 VGND VNB sky130_fd_pr__nfet_01v8 w=650000u l=150000u
X2 n1 A2 VGND VNB sky130_fd_pr__nfet_01v8 w=650000u l=150000u
X3 Y B1 VPWR VPB sky130_fd_pr__pfet_01v8_hvt w=700000u l=150000u
X4 Y A2 p1 VPB sky130_fd_pr__pfet_01v8_hvt w=1000000u l=150000u
X5 p1 A1 VPWR VPB sky130_fd_pr__pfet_01v8_hvt w=1000000u l=150000u
.ends
