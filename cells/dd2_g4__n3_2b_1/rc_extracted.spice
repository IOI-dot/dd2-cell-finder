* NGSPICE file created from dd2_g4__n3_2b_1.ext - technology: sky130A

.subckt dd2_g4__n3_2b_1 A B C VGND VNB VPB VPWR Y
X0 Y.t3 B.t2 a_350_297.t3 VPB.t5 sky130_fd_pr__pfet_01v8_hvt ad=0.135 pd=1.27 as=0.3175 ps=1.635 w=1 l=0.15 sa=2.25 sb=1.465
X1 a_350_297.t2 a_27_47.t5 a_266_297.t0 VPB.t2 sky130_fd_pr__pfet_01v8_hvt ad=0.3175 pd=1.635 as=0.135 ps=1.27 w=1 l=0.15 sa=1.465 sb=2.25
X2 VGND.t2 a_27_47.t3 a_266_47.t1 VNB.t2 sky130_fd_pr__nfet_01v8 ad=0.20638 pd=1.285 as=0.08775 ps=0.92 w=0.65 l=0.15 sa=1.465 sb=2.25
X3 a_266_297.t1 B.t3 VPWR.t0 VPB.t4 sky130_fd_pr__pfet_01v8_hvt ad=0.135 pd=1.27 as=0.3175 ps=1.635 w=1 l=0.15 sa=1.045 sb=2.67
X4 Y.t2 a_27_47.t2 a_507_47.t0 VNB.t1 sky130_fd_pr__nfet_01v8 ad=0.20638 pd=1.285 as=0.08775 ps=0.92 w=0.65 l=0.15 sa=2.67 sb=1.045
X5 a_266_47.t2 B.t1 VGND.t3 VNB.t4 sky130_fd_pr__nfet_01v8 ad=0.08775 pd=0.92 as=0.20638 ps=1.285 w=0.65 l=0.15 sa=1.045 sb=2.67
X6 a_507_47.t1 B.t0 VGND.t0 VNB.t5 sky130_fd_pr__nfet_01v8 ad=0.08775 pd=0.92 as=0.20638 ps=1.285 w=0.65 l=0.15 sa=2.25 sb=1.465
X7 VPWR.t2 C.t1 a_350_297.t0 VPB.t0 sky130_fd_pr__pfet_01v8_hvt ad=0.26 pd=2.52 as=0.3175 ps=1.635 w=1 l=0.15 sa=3.455 sb=0.26
X8 a_266_47.t0 C.t0 Y.t1 VNB.t0 sky130_fd_pr__nfet_01v8 ad=0.169 pd=1.82 as=0.20638 ps=1.285 w=0.65 l=0.15 sa=3.455 sb=0.26
X9 a_350_297.t1 a_27_47.t4 Y.t0 VPB.t1 sky130_fd_pr__pfet_01v8_hvt ad=0.3175 pd=1.635 as=0.135 ps=1.27 w=1 l=0.15 sa=2.67 sb=1.045
X10 VPWR.t1 A.t1 a_27_47.t0 VPB.t3 sky130_fd_pr__pfet_01v8_hvt ad=0.3175 pd=1.635 as=0.26 ps=2.52 w=1 l=0.15 sa=0.26 sb=3.455
X11 VGND.t1 A.t0 a_27_47.t1 VNB.t3 sky130_fd_pr__nfet_01v8 ad=0.20638 pd=1.285 as=0.169 ps=1.82 w=0.65 l=0.15 sa=0.26 sb=3.455
R0 VGND VGND.n0 0.299711
R1 VGND.n0 VGND.n1 214.093
R2 VGND.n0 VGND.n2 132.686
R3 VGND.n2 VGND.t1 59.0774
R4 VGND.n2 VGND.t3 58.1543
R5 VGND.n1 VGND.t2 58.1543
R6 VGND.n1 VGND.t0 59.0774
R7 Y.n1 Y.n0 185
R8 Y.n0 Y 194.892
R9 Y Y.n1 3.29747
R10 Y.n3 Y.n2 585
R11 Y Y.n3 6.4005
R12 Y.n3 Y.n1 25.3034
R13 Y.n2 Y.t3 26.5955
R14 Y.n2 Y.t0 26.5955
R15 Y.n0 Y.t2 59.0774
R16 Y.n0 Y.t1 58.1543
R17 VPWR VPWR.n0 0.192387
R18 VPWR.n0 VPWR.t2 267.378
R19 VPWR.n0 VPWR.n1 619.307
R20 VPWR.n1 VPWR.t1 63.0405
R21 VPWR.n1 VPWR.t0 62.0555
R22 C C.n0 158.4
R23 C.n0 C.t0 169.237
R24 C.n0 C.t1 241.536
R25 B.n1 B.n0 152
R26 B B.n1 6.4005
R27 B.n3 B.n1 25.192
R28 B B.n3 0.376971
R29 B.n3 B.n2 158.024
R30 B.n2 B.t0 169.237
R31 B.n2 B.t2 241.536
R32 B.n0 B.t1 169.237
R33 B.n0 B.t3 241.536
R34 A A.n0 158.4
R35 A.n0 A.t0 158.064
R36 A.n0 A.t1 230.363
R37 VPB VPB.t3 192.369
R38 VPB.t3 VPB.t4 464.642
R39 VPB.t4 VPB.t2 248.599
R40 VPB.t2 VPB.t5 464.642
R41 VPB.t5 VPB.t1 248.599
R42 VPB.t1 VPB.t0 464.642
R43 VNB VNB.t3 925.567
R44 VNB.t3 VNB.t4 2235.6
R45 VNB.t4 VNB.t2 1196.12
R46 VNB.t2 VNB.t5 2235.6
R47 VNB.t5 VNB.t1 1196.12
R48 VNB.t1 VNB.t0 2235.6
R49 a_507_47.t0 a_507_47.t1 49.8467
R50 a_266_47.t0 a_266_47.n0 252.417
R51 a_266_47.n0 a_266_47.t2 24.9236
R52 a_266_47.n0 a_266_47.t1 24.9236
R53 a_350_297.n0 a_350_297.n1 462.079
R54 a_350_297.n0 a_350_297.t1 63.0405
R55 a_350_297.t0 a_350_297.n0 62.0555
R56 a_350_297.n1 a_350_297.t2 62.0555
R57 a_350_297.n1 a_350_297.t3 63.0405
R58 a_266_297.t0 a_266_297.t1 53.1905
R59 a_27_47.t0 a_27_47.n3 228.773
R60 a_27_47.n3 a_27_47.t1 198.087
R61 a_27_47.n1 a_27_47.n0 152
R62 a_27_47.n3 a_27_47.n1 135.906
R63 a_27_47.n1 a_27_47.n2 268.329
R64 a_27_47.n2 a_27_47.t2 158.064
R65 a_27_47.n2 a_27_47.t4 230.363
R66 a_27_47.n0 a_27_47.t3 158.064
R67 a_27_47.n0 a_27_47.t5 230.363
C0 B VGND 0.06034f
C1 A VPB 0.04223f
C2 Y C 0.00875f
C3 VPB VGND 0.00567f
C4 VGND C 0.0154f
C5 B VPWR 0.02203f
C6 VGND Y 0.06431f
C7 VPB VPWR 0.1163f
C8 A VGND 0.03025f
C9 VPWR C 0.02425f
C10 Y VPWR 0.00542f
C11 B VPB 0.06443f
C12 A VPWR 0.01643f
C13 VGND VPWR 0.0129f
C14 B Y 0.02542f
C15 VPB C 0.03703f
C16 B A 0.02541f
C17 VPB Y 0.00882f
C18 VGND VNB 0.22138f
C19 Y VNB 0f
C20 VPWR VNB 0f
C21 C VNB 0.06363f
C22 B VNB 0f
C23 A VNB 0.05034f
C24 VPB VNB 0.55473f
C25 a_27_47.t0 VNB 0.10803f
C26 a_27_47.n0 VNB 0.06977f
C27 a_27_47.n1 VNB 0.14666f
C28 a_27_47.n2 VNB 0.09631f
C29 a_27_47.n3 VNB 0.231f
C30 a_27_47.t1 VNB 0.09218f
C31 a_266_297.t0 VNB 0.041f
C32 a_266_297.t1 VNB 0.04823f
C33 a_350_297.t0 VNB 0.05697f
C34 a_350_297.n0 VNB 0.13694f
C35 a_350_297.n1 VNB 0.13694f
C36 a_350_297.t2 VNB 0.05699f
C37 a_350_297.t3 VNB 0.06473f
C38 a_350_297.t1 VNB 0.0575f
C39 a_266_47.t0 VNB 0.35899f
C40 a_266_47.n0 VNB 0.43027f
C41 a_266_47.t2 VNB 0.03971f
C42 a_266_47.t1 VNB 0.03445f
C43 a_507_47.t0 VNB 0.02795f
C44 a_507_47.t1 VNB 0.0332f
C45 VPB.t0 VNB 0.09475f
C46 VPB.t1 VNB 0.05398f
C47 VPB.t2 VNB 0.05398f
C48 VPB.t3 VNB 0.04973f
C49 VPB.t4 VNB 0.05398f
C50 VPB.t5 VNB 0.05398f
C51 A.n0 VNB 0.07453f
C52 B.n0 VNB 0.0644f
C53 B.n1 VNB 0.06191f
C54 B.n2 VNB 0.06496f
C55 B.n3 VNB 0.09941f
C56 C.n0 VNB 0.05034f
C57 VPWR.n0 VNB 0.4081f
C58 VPWR.t1 VNB 0.05181f
C59 VPWR.t0 VNB 0.05712f
C60 VPWR.n1 VNB 0.05111f
C61 VPWR.t2 VNB 0.06884f
C62 Y.n0 VNB 0.05675f
C63 Y.t2 VNB 0.04611f
C64 Y.t1 VNB 0.04568f
C65 Y.n1 VNB 0.07647f
C66 Y.t3 VNB 0.05041f
C67 Y.t0 VNB 0.04318f
C68 Y.n2 VNB 0.0365f
C69 Y.n3 VNB 0.04734f
C70 VGND.n0 VNB 0.21663f
C71 VGND.t2 VNB 0.03065f
C72 VGND.t0 VNB 0.03611f
C73 VGND.n1 VNB 0.02722f
C74 VGND.n2 VNB 0.0309f
C75 VGND.t1 VNB 0.03195f
C76 VGND.t3 VNB 0.03591f
.ends
