* NGSPICE file created from dd2_ref__mux2_1.ext - technology: sky130A

.subckt dd2_ref__mux2_1 A0 A1 S VGND VNB VPB VPWR X
X0 a_253_297.t0 S.t3 VPWR.t1 VPB.t0 sky130_fd_pr__pfet_01v8_hvt ad=0.26 pd=2.52 as=0.165 ps=1.33 w=1 l=0.15 sa=1.66 sb=0.26
X1 a_93_199.t1 a_389_21.t2 a_335_47.t0 VNB.t2 sky130_fd_pr__nfet_01v8 ad=0.11375 pd=1 as=0.08775 ps=0.92 w=0.65 l=0.15 sa=1.62 sb=2.18
X2 a_389_21.t0 S.t0 VGND.t0 VNB.t1 sky130_fd_pr__nfet_01v8 ad=0.169 pd=1.82 as=0.25675 ps=1.44 w=0.65 l=0.15 sa=3.54 sb=0.26
X3 VPWR.t2 A1.t1 a_253_297.t2 VPB.t4 sky130_fd_pr__pfet_01v8_hvt ad=0.165 pd=1.33 as=0.175 ps=1.35 w=1 l=0.15 sa=1.18 sb=0.74
X4 a_253_297.t1 a_389_21.t3 a_93_199.t2 VPB.t2 sky130_fd_pr__pfet_01v8_hvt ad=0.175 pd=1.35 as=0.135 ps=1.27 w=1 l=0.15 sa=0.68 sb=1.24
X5 a_389_21.t1 S.t2 VPWR.t0 VPB.t1 sky130_fd_pr__pfet_01v8_hvt ad=0.26 pd=2.52 as=0.26 ps=2.52 w=1 l=0.15 sa=0.26 sb=0.26
X6 VGND.t2 a_93_199.t4 X.t1 VNB.t3 sky130_fd_pr__nfet_01v8 ad=0.25675 pd=1.44 as=0.169 ps=1.82 w=0.65 l=0.15 sa=0.26 sb=3.54
X7 VPWR.t3 a_93_199.t5 X.t0 VPB.t3 sky130_fd_pr__pfet_01v8_hvt ad=0.26 pd=2.52 as=0.26 ps=2.52 w=1 l=0.15 sa=0.26 sb=0.26
X8 VGND.t1 S.t1 a_519_47.t0 VNB.t0 sky130_fd_pr__nfet_01v8 ad=0.25675 pd=1.44 as=0.10725 ps=0.98 w=0.65 l=0.15 sa=2.6 sb=1.2
X9 a_93_199.t3 A0.t1 a_253_297.t3 VPB.t5 sky130_fd_pr__pfet_01v8_hvt ad=0.135 pd=1.27 as=0.26 ps=2.52 w=1 l=0.15 sa=0.26 sb=1.66
X10 a_335_47.t1 A0.t0 VGND.t3 VNB.t5 sky130_fd_pr__nfet_01v8 ad=0.08775 pd=0.92 as=0.25675 ps=1.44 w=0.65 l=0.15 sa=1.2 sb=2.6
X11 a_519_47.t1 A1.t0 a_93_199.t0 VNB.t4 sky130_fd_pr__nfet_01v8 ad=0.10725 pd=0.98 as=0.11375 ps=1 w=0.65 l=0.15 sa=2.12 sb=1.68
R0 VGND VGND.n0 0.260336
R1 VGND.n0 VGND.n1 128.727
R2 VGND.n0 VGND.n2 214.631
R3 VGND.n2 VGND.t2 72.9236
R4 VGND.n2 VGND.t3 72.9236
R5 VGND.n1 VGND.t1 72.9236
R6 VGND.n1 VGND.t0 72.9236
R7 VPWR.n2 VPWR.n1 9.3005
R8 VPWR.n4 VPWR.n3 9.3005
R9 VPWR.n6 VPWR.n5 9.3005
R10 VPWR.n8 VPWR.n7 9.3005
R11 VPWR VPWR.n0 0.121778
R12 VPWR.n0 VPWR.n2 0.141672
R13 VPWR.n2 VPWR.n4 0.120292
R14 VPWR.n4 VPWR.n6 0.120292
R15 VPWR.n6 VPWR.n8 0.120292
R16 VPWR.n8 VPWR.n9 0.833096
R17 VPWR.n9 VPWR.t0 359.216
R18 VPWR.n0 VPWR.n10 21.212
R19 VPWR.n10 VPWR.n1 21.0829
R20 VPWR.n1 VPWR.n3 34.6358
R21 VPWR.n3 VPWR.n5 34.6358
R22 VPWR.n5 VPWR.n7 34.6358
R23 VPWR.n7 VPWR.n12 17.3181
R24 VPWR.n9 VPWR.n12 24.2329
R25 VPWR.n12 VPWR.n11 607.212
R26 VPWR.n11 VPWR.t2 32.5055
R27 VPWR.n11 VPWR.t1 32.5055
R28 VPWR.n10 VPWR.t3 347.57
R29 X.n1 X.n0 73.9198
R30 X X.n1 3.29747
R31 X.n1 X.t0 228.772
R32 X X.n0 1.64144
R33 X.n0 X.t1 133.386
R34 S.n0 S.n1 137.298
R35 S S.n0 167.165
R36 S.n1 S.t3 212.081
R37 S.n1 S.t1 139.78
R38 S.n0 S.t2 212.081
R39 S.n0 S.t0 139.78
R40 A1 A1.n0 158.4
R41 A1.n0 A1.t0 169.237
R42 A1.n0 A1.t1 241.536
R43 A0 A0.n0 158.4
R44 A0.n0 A0.t0 169.237
R45 A0.n0 A0.t1 241.536
R46 VPB VPB.t3 304.829
R47 VPB.t3 VPB.t5 556.386
R48 VPB.t5 VPB.t2 248.599
R49 VPB.t2 VPB.t4 295.95
R50 VPB.t4 VPB.t0 284.113
R51 VPB.t0 VPB.t1 556.386
R52 VNB VNB.t3 1466.67
R53 VNB.t3 VNB.t5 2677.02
R54 VNB.t5 VNB.t2 1196.12
R55 VNB.t2 VNB.t4 1423.95
R56 VNB.t4 VNB.t0 1366.99
R57 VNB.t0 VNB.t1 2677.02
R58 a_519_47.t0 a_519_47.t1 60.9236
R59 a_335_47.t0 a_335_47.t1 49.8467
R60 a_253_297.t0 a_253_297.n0 389.599
R61 a_253_297.n0 a_253_297.n1 292.5
R62 a_253_297.n0 a_253_297.t3 383.767
R63 a_253_297.n1 a_253_297.t1 34.4755
R64 a_253_297.n1 a_253_297.t2 34.4755
R65 a_389_21.t1 a_389_21.n0 218.792
R66 a_389_21.n0 a_389_21.n1 334.026
R67 a_389_21.n1 a_389_21.t2 169.237
R68 a_389_21.n1 a_389_21.t3 241.536
R69 a_389_21.n0 a_389_21.t0 242.915
R70 a_93_199.n0 a_93_199.t3 26.5955
R71 a_93_199.t2 a_93_199.n0 26.5955
R72 a_93_199.n0 a_93_199.n2 655.777
R73 a_93_199.n2 a_93_199.n3 191.154
R74 a_93_199.n3 a_93_199.t4 169.237
R75 a_93_199.n3 a_93_199.t5 241.536
R76 a_93_199.n2 a_93_199.n1 191.476
R77 a_93_199.n1 a_93_199.t1 32.3082
R78 a_93_199.n1 a_93_199.t0 32.3082
C0 VPB VPWR 0.14508f
C1 S VGND 0.05205f
C2 X S 0
C3 A1 VGND 0.01982f
C4 X A1 0
C5 VPB VGND 0.01527f
C6 VPB X 0.02147f
C7 VPWR VGND 0.05223f
C8 X VPWR 0.06166f
C9 A0 VPB 0.03141f
C10 A0 VPWR 0.01026f
C11 S A1 0.03175f
C12 X VGND 0.04595f
C13 VPB S 0.09844f
C14 VPB A1 0.02789f
C15 S VPWR 0.03901f
C16 A1 VPWR 0.01592f
C17 A0 VGND 0.01532f
C18 A0 X 0
C19 VGND VNB 0.155f
C20 VPWR VNB 0f
C21 X VNB 0f
C22 S VNB 0.05353f
C23 A1 VNB 0.0235f
C24 A0 VNB 0.02962f
C25 VPB VNB 0.59583f
C26 a_93_199.t2 VNB 0.04043f
C27 a_93_199.n0 VNB 0.04087f
C28 a_93_199.n1 VNB 0.06947f
C29 a_93_199.t1 VNB 0.03145f
C30 a_93_199.t0 VNB 0.03551f
C31 a_93_199.n2 VNB 0.15751f
C32 a_93_199.n3 VNB 0.04615f
C33 a_93_199.t3 VNB 0.04663f
C34 a_389_21.t1 VNB 0.08923f
C35 a_389_21.n0 VNB 0.23649f
C36 a_389_21.t0 VNB 0.09927f
C37 a_389_21.n1 VNB 0.08576f
C38 a_253_297.t0 VNB 0.08899f
C39 a_253_297.n0 VNB 0.15732f
C40 a_253_297.n1 VNB 0.04119f
C41 a_253_297.t1 VNB 0.04238f
C42 a_253_297.t2 VNB 0.04799f
C43 a_253_297.t3 VNB 0.09565f
C44 a_335_47.t0 VNB 0.02498f
C45 a_335_47.t1 VNB 0.02946f
C46 a_519_47.t0 VNB 0.02696f
C47 a_519_47.t1 VNB 0.03205f
C48 VPB.t0 VNB 0.06797f
C49 VPB.t1 VNB 0.12637f
C50 VPB.t2 VNB 0.04404f
C51 VPB.t3 VNB 0.06965f
C52 VPB.t4 VNB 0.04691f
C53 VPB.t5 VNB 0.0651f
C54 A0.n0 VNB 0.0567f
C55 A1.n0 VNB 0.0555f
C56 S.n0 VNB 0.08782f
C57 S.n1 VNB 0.07667f
C58 X.n0 VNB 0.02757f
C59 X.t1 VNB 0.03945f
C60 X.n1 VNB 0.0681f
C61 X.t0 VNB 0.06528f
C62 VPWR.n0 VNB 0.04276f
C63 VPWR.n1 VNB 0.01004f
C64 VPWR.n2 VNB 0.0406f
C65 VPWR.n3 VNB 0.01249f
C66 VPWR.n4 VNB 0.03526f
C67 VPWR.n5 VNB 0.01249f
C68 VPWR.n6 VNB 0.03526f
C69 VPWR.n7 VNB 0.00937f
C70 VPWR.n8 VNB 0.16698f
C71 VPWR.n9 VNB 0.07459f
C72 VPWR.t3 VNB 0.06164f
C73 VPWR.n10 VNB 0.03294f
C74 VPWR.t2 VNB 0.04064f
C75 VPWR.t1 VNB 0.03425f
C76 VPWR.n11 VNB 0.02666f
C77 VPWR.n12 VNB 0.02137f
C78 VPWR.t0 VNB 0.06289f
C79 VGND.n0 VNB 0.27382f
C80 VGND.n1 VNB 0.03064f
C81 VGND.t1 VNB 0.02775f
C82 VGND.t0 VNB 0.02775f
C83 VGND.t2 VNB 0.02818f
C84 VGND.t3 VNB 0.03328f
C85 VGND.n2 VNB 0.02718f
.ends
