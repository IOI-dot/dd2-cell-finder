* NGSPICE file created from dd2_t_nor2.ext - technology: sky130A

.subckt dd2_t_nor2 A B VGND VNB VPB VPWR Y
X0 a_111_297.t0 B.t1 VPWR.t0 VPB.t0 sky130_fd_pr__pfet_01v8_hvt ad=0.135 pd=1.27 as=0.26 ps=2.52 w=1 l=0.15 sa=0.26 sb=0.68
X1 VGND.t0 A.t0 Y.t0 VNB.t1 sky130_fd_pr__nfet_01v8 ad=0.169 pd=1.82 as=0.08775 ps=0.92 w=0.65 l=0.15 sa=0.68 sb=0.26
X2 Y.t1 B.t0 VGND.t1 VNB.t0 sky130_fd_pr__nfet_01v8 ad=0.08775 pd=0.92 as=0.169 ps=1.82 w=0.65 l=0.15 sa=0.26 sb=0.68
X3 Y.t2 A.t1 a_111_297.t1 VPB.t1 sky130_fd_pr__pfet_01v8_hvt ad=0.26 pd=2.52 as=0.135 ps=1.27 w=1 l=0.15 sa=0.68 sb=0.26
R0 VGND VGND.n0 0.567428
R1 VGND.n0 VGND.t0 169.233
R2 VGND.n0 VGND.t1 169.06
R3 Y.n1 Y.n2 89.3175
R4 Y Y.n1 9.66497
R5 Y.n0 Y.t2 219.225
R6 Y.n0 Y.n1 75.3279
R7 Y Y.n0 5.48951
R8 Y.n2 Y.t1 24.9236
R9 Y.n2 Y.t0 24.9236
R10 VPWR VPWR.t0 266.878
R11 A A.n0 158.4
R12 A.n0 A.t0 158.064
R13 A.n0 A.t1 230.363
R14 B B.n0 158.4
R15 B.n0 B.t0 158.064
R16 B.n0 B.t1 230.363
R17 VPB VPB.t0 198.287
R18 VPB.t0 VPB.t1 248.599
R19 VNB VNB.t0 954.045
R20 VNB.t0 VNB.t1 1196.12
R21 a_111_297.t0 a_111_297.t1 53.1905
C0 A Y 0.05773f
C1 B VPB 0.03893f
C2 Y VPWR 0.08811f
C3 VGND Y 0.08161f
C4 A VPB 0.03824f
C5 A B 0.02548f
C6 VPWR VPB 0.04959f
C7 B VPWR 0.03756f
C8 VGND VPB 0.00503f
C9 B VGND 0.0354f
C10 A VPWR 0.00887f
C11 Y VPB 0.0151f
C12 B Y 0.03188f
C13 A VGND 0.03393f
C14 VGND VPWR 0.0171f
C15 VGND VNB 0.20112f
C16 Y VNB 0f
C17 VPWR VNB 0.30379f
C18 A VNB 0.05868f
C19 B VNB 0.05729f
C20 VPB VNB 0.27596f
C21 a_111_297.t0 VNB 0.03408f
C22 a_111_297.t1 VNB 0.03337f
C23 VPB.t0 VNB 0.03151f
C24 VPB.t1 VNB 0.07344f
C25 B.n0 VNB 0.06825f
C26 A.n0 VNB 0.06624f
C27 VPWR.t0 VNB 0.06608f
C28 Y.n0 VNB 0.0813f
C29 Y.n1 VNB 0.04069f
C30 Y.n2 VNB 0.01959f
C31 Y.t1 VNB 0.02728f
C32 Y.t0 VNB 0.02676f
C33 Y.t2 VNB 0.07638f
C34 VGND.n0 VNB 0.06117f
C35 VGND.t0 VNB 0.03665f
C36 VGND.t1 VNB 0.0371f
.ends
