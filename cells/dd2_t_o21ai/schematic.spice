.subckt dd2_t_o21ai A B C VGND VNB VPB VPWR Y
X0 Y C n1 VNB sky130_fd_pr__nfet_01v8 w=650000u l=150000u
X1 n1 A VGND VNB sky130_fd_pr__nfet_01v8 w=650000u l=150000u
X2 n1 B VGND VNB sky130_fd_pr__nfet_01v8 w=650000u l=150000u
X3 Y C VPWR VPB sky130_fd_pr__pfet_01v8_hvt w=1000000u l=150000u
X4 Y A p1 VPB sky130_fd_pr__pfet_01v8_hvt w=1000000u l=150000u
X5 p1 B VPWR VPB sky130_fd_pr__pfet_01v8_hvt w=1000000u l=150000u
.ends
