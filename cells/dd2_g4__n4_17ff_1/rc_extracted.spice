* NGSPICE file created from dd2_g4__n4_17ff_1.ext - technology: sky130A

.subckt dd2_g4__n4_17ff_1 A B C D VGND VNB VPB VPWR Y
X0 a_237_47.t2 A.t1 a_137_47.t0 VNB.t2 sky130_fd_pr__nfet_01v8 ad=0.169 pd=1.82 as=0.11375 ps=1 w=0.65 l=0.15 sa=0.76 sb=0.26
X1 a_237_47.t1 C.t0 a_521_47.t0 VNB.t1 sky130_fd_pr__nfet_01v8 ad=0.11375 pd=1 as=0.11375 ps=1 w=0.65 l=0.15 sa=1.24 sb=0.76
X2 VPWR.t0 C.t1 a_237_297.t0 VPB.t1 sky130_fd_pr__pfet_01v8_hvt ad=0.175 pd=1.35 as=0.175 ps=1.35 w=1 l=0.15 sa=2.68 sb=0.76
X3 a_137_47.t1 B.t1 VGND.t1 VNB.t4 sky130_fd_pr__nfet_01v8 ad=0.11375 pd=1 as=0.169 ps=1.82 w=0.65 l=0.15 sa=0.26 sb=0.76
X4 a_521_47.t1 B.t0 VGND.t0 VNB.t5 sky130_fd_pr__nfet_01v8 ad=0.11375 pd=1 as=0.10725 ps=0.98 w=0.65 l=0.15 sa=0.74 sb=1.26
X5 a_237_297.t2 A.t3 a_137_297.t0 VPB.t2 sky130_fd_pr__pfet_01v8_hvt ad=0.395 pd=1.79 as=0.175 ps=1.35 w=1 l=0.15 sa=0.76 sb=2.68
X6 VGND.t2 A.t0 a_343_47# VNB.t3 sky130_fd_pr__nfet_01v8 ad=0.10725 pd=0.98 as=0.169 ps=1.82 w=0.65 l=0.15 sa=0.26 sb=1.74
X7 Y.t3 A.t2 a_237_297.t1 VPB.t3 sky130_fd_pr__pfet_01v8_hvt ad=0.165 pd=1.33 as=0.395 ps=1.79 w=1 l=0.15 sa=1.7 sb=1.74
X8 a_237_297.t3 B.t2 Y.t0 VPB.t5 sky130_fd_pr__pfet_01v8_hvt ad=0.175 pd=1.35 as=0.165 ps=1.33 w=1 l=0.15 sa=2.18 sb=1.26
X9 a_137_297.t1 B.t3 VPWR.t2 VPB.t4 sky130_fd_pr__pfet_01v8_hvt ad=0.175 pd=1.35 as=0.26 ps=2.52 w=1 l=0.15 sa=0.26 sb=3.18
X10 Y.t2 D.t0 a_237_47.t0 VNB.t0 sky130_fd_pr__nfet_01v8 ad=0.169 pd=1.82 as=0.11375 ps=1 w=0.65 l=0.15 sa=1.74 sb=0.26
X11 Y.t1 D.t1 VPWR.t1 VPB.t0 sky130_fd_pr__pfet_01v8_hvt ad=0.26 pd=2.52 as=0.175 ps=1.35 w=1 l=0.15 sa=3.18 sb=0.26
R0 VGND VGND.n0 0.0973694
R1 VGND.n0 VGND.n1 220.082
R2 VGND.n0 VGND.t1 172.798
R3 VGND.n1 VGND.t2 30.462
R4 VGND.n1 VGND.t0 30.462
R5 Y Y.n4 6.8005
R6 Y Y.n4 3.2005
R7 Y.n4 Y.n0 0.2005
R8 Y.n0 Y.n1 68.3417
R9 Y.n1 Y.n2 96.7534
R10 Y.n2 Y.n3 295.762
R11 Y Y.n2 3.29747
R12 Y.n3 Y.t3 32.5055
R13 Y.n3 Y.t0 32.5055
R14 Y.n1 Y.t1 227.356
R15 Y.n0 Y.t2 268.077
R16 VPWR VPWR.n0 0.0861569
R17 VPWR.n0 VPWR.n1 619.973
R18 VPWR.n1 VPWR.t0 34.4755
R19 VPWR.n1 VPWR.t1 34.4755
R20 VPWR.n0 VPWR.t2 360.158
R21 D D.n0 158.4
R22 D.n0 D.t0 169.237
R23 D.n0 D.t1 241.536
R24 C C.n0 158.4
R25 C.n0 C.t0 169.237
R26 C.n0 C.t1 241.536
R27 A A.n1 167.165
R28 A.n1 A.n0 137.298
R29 A.n1 A.t3 212.081
R30 A.n1 A.t1 139.78
R31 A.n0 A.t2 212.081
R32 A.n0 A.t0 139.78
R33 B.n1 B.n0 152
R34 B B.n1 3.29747
R35 B B.n1 161.038
R36 B B.n2 158.4
R37 B.n2 B.t0 169.237
R38 B.n2 B.t2 241.536
R39 B.n0 B.t1 169.237
R40 B.n0 B.t3 241.536
R41 VPB VPB.t4 275.235
R42 VPB.t4 VPB.t2 295.95
R43 VPB.t2 VPB.t3 556.386
R44 VPB.t3 VPB.t5 284.113
R45 VPB.t5 VPB.t1 295.95
R46 VPB.t1 VPB.t0 295.95
R47 VNB VNB.t4 1324.27
R48 VNB.t4 VNB.t2 1423.95
R49 VNB.t2 VNB.t3 2677.02
R50 VNB.t3 VNB.t5 1366.99
R51 VNB.t5 VNB.t1 1423.95
R52 VNB.t1 VNB.t0 1423.95
R53 a_521_47.t0 a_521_47.t1 64.6159
R54 a_237_47.n0 a_237_47.t2 370.846
R55 a_237_47.n0 a_237_47.t1 32.3082
R56 a_237_47.t0 a_237_47.n0 32.3082
R57 a_137_47.t0 a_137_47.t1 64.6159
R58 a_237_297.n0 a_237_297.t3 34.4755
R59 a_237_297.t0 a_237_297.n0 34.4755
R60 a_237_297.n0 a_237_297.n1 958.691
R61 a_237_297.n1 a_237_297.t2 77.8155
R62 a_237_297.n1 a_237_297.t1 77.8155
R63 a_137_297.t0 a_137_297.t1 68.9505
C0 A Y 0.00607f
C1 VGND D 0.01649f
C2 C VPWR 0.01683f
C3 VPB VPWR 0.12593f
C4 VGND Y 0.02204f
C5 B VPWR 0.05097f
C6 a_343_47# VPWR 0
C7 A VGND 0.03977f
C8 VPWR D 0.01603f
C9 C VPB 0.02845f
C10 Y VPWR 0.08198f
C11 C B 0.0316f
C12 B VPB 0.07664f
C13 A VPWR 0.02949f
C14 C D 0.03085f
C15 VPB D 0.03246f
C16 VGND VPWR 0.04633f
C17 C Y 0.02537f
C18 B D 0
C19 VPB Y 0.0235f
C20 B Y 0.03365f
C21 A VPB 0.09376f
C22 A B 0.12963f
C23 C VGND 0.01313f
C24 Y D 0.04414f
C25 A a_343_47# 0.00316f
C26 VPB VGND 0.01262f
C27 B VGND 0.05209f
C28 a_343_47# VGND 0.02856f
C29 VGND VNB 0.20173f
C30 Y VNB 0f
C31 VPWR VNB 0f
C32 D VNB 0.05338f
C33 C VNB 0.02011f
C34 A VNB 0.01442f
C35 B VNB 0.06008f
C36 VPB VNB 0.56975f
C37 a_343_47# VNB 0.01912f
C38 a_137_297.t0 VNB 0.04085f
C39 a_137_297.t1 VNB 0.04583f
C40 a_237_297.t0 VNB 0.04421f
C41 a_237_297.n0 VNB 0.05388f
C42 a_237_297.n1 VNB 0.11554f
C43 a_237_297.t2 VNB 0.05806f
C44 a_237_297.t1 VNB 0.05806f
C45 a_237_297.t3 VNB 0.04355f
C46 a_137_47.t0 VNB 0.02995f
C47 a_137_47.t1 VNB 0.03407f
C48 a_237_47.t0 VNB 0.03502f
C49 a_237_47.n0 VNB 0.14584f
C50 a_237_47.t2 VNB 0.15028f
C51 a_237_47.t1 VNB 0.03799f
C52 a_521_47.t0 VNB 0.05087f
C53 a_521_47.t1 VNB 0.05039f
C54 VPB.t0 VNB 0.09331f
C55 VPB.t1 VNB 0.04443f
C56 VPB.t2 VNB 0.06398f
C57 VPB.t3 VNB 0.06309f
C58 VPB.t4 VNB 0.04288f
C59 VPB.t5 VNB 0.04354f
C60 B.n0 VNB 0.05614f
C61 B.n1 VNB 0.08713f
C62 B.n2 VNB 0.05666f
C63 A.n0 VNB 0.0839f
C64 A.n1 VNB 0.0961f
C65 C.n0 VNB 0.058f
C66 D.n0 VNB 0.04969f
C67 VPWR.n0 VNB 0.39311f
C68 VPWR.t2 VNB 0.06705f
C69 VPWR.t0 VNB 0.04172f
C70 VPWR.t1 VNB 0.03761f
C71 VPWR.n1 VNB 0.02706f
C72 Y.t2 VNB 0.04719f
C73 Y.n0 VNB 0.02653f
C74 Y.t1 VNB 0.07247f
C75 Y.n1 VNB 0.08632f
C76 Y.n2 VNB 0.05128f
C77 Y.n3 VNB 0.0327f
C78 Y.t3 VNB 0.03923f
C79 Y.t0 VNB 0.04421f
C80 Y.n4 VNB 0.00666f
C81 VGND.n0 VNB 0.28349f
C82 VGND.t2 VNB 0.02252f
C83 VGND.t0 VNB 0.02664f
C84 VGND.n1 VNB 0.01494f
C85 VGND.t1 VNB 0.04104f
.ends
