* NGSPICE file created from dd2_t_xor3.ext - technology: sky130A

.subckt dd2_t_xor3 A B C VGND VNB VPB VPWR Y
X0 a_341_297.t2 A.t2 VPWR.t1 VPB.t5 sky130_fd_pr__pfet_01v8_hvt ad=0.4 pd=1.8 as=0.135 ps=1.27 w=1 l=0.15 sa=0.68 sb=1.21
X1 a_1263_297.t0 a_885_47.t4 Y.t0 VPB.t2 sky130_fd_pr__pfet_01v8_hvt ad=0.4 pd=1.8 as=0.26 ps=2.52 w=1 l=0.15 sa=0.26 sb=1.63
X2 Y.t1 a_885_47.t3 VGND.t5 VNB.t8 sky130_fd_pr__nfet_01v8 ad=0.26 pd=1.45 as=0.25675 ps=1.44 w=0.65 l=0.15 sa=5.83 sb=1.63
X3 VGND.t0 a_149_47.t3 a_507_47.t0 VNB.t0 sky130_fd_pr__nfet_01v8 ad=0.25675 pd=1.44 as=0.26 ps=1.45 w=0.65 l=0.15 sa=3 sb=4.46
X4 VPWR.t2 B.t2 a_341_297.t0 VPB.t1 sky130_fd_pr__pfet_01v8_hvt ad=0.135 pd=1.27 as=0.26 ps=2.52 w=1 l=0.15 sa=0.26 sb=1.63
X5 VGND.t1 A.t1 a_149_47.t1 VNB.t4 sky130_fd_pr__nfet_01v8 ad=0.26 pd=1.45 as=0.08775 ps=0.92 w=0.65 l=0.15 sa=0.68 sb=6.78
X6 a_1453_47.t1 a_507_47.t3 Y.t2 VNB.t9 sky130_fd_pr__nfet_01v8 ad=0.08775 pd=0.92 as=0.26 ps=1.45 w=0.65 l=0.15 sa=6.78 sb=0.68
X7 a_149_47.t0 B.t1 VGND.t2 VNB.t1 sky130_fd_pr__nfet_01v8 ad=0.08775 pd=0.92 as=0.169 ps=1.82 w=0.65 l=0.15 sa=0.26 sb=7.2
X8 a_885_47.t1 C.t1 VGND.t7 VNB.t6 sky130_fd_pr__nfet_01v8 ad=0.26 pd=1.45 as=0.25675 ps=1.44 w=0.65 l=0.15 sa=3.94 sb=3.52
X9 a_423_47.t0 B.t0 VGND.t3 VNB.t2 sky130_fd_pr__nfet_01v8 ad=0.08775 pd=0.92 as=0.26 ps=1.45 w=0.65 l=0.15 sa=1.63 sb=5.83
X10 VGND.t6 C.t0 a_1453_47.t0 VNB.t7 sky130_fd_pr__nfet_01v8 ad=0.169 pd=1.82 as=0.08775 ps=0.92 w=0.65 l=0.15 sa=7.2 sb=0.26
X11 a_1263_297.t1 C.t2 VPWR.t4 VPB.t7 sky130_fd_pr__pfet_01v8_hvt ad=0.26 pd=2.52 as=0.135 ps=1.27 w=1 l=0.15 sa=1.63 sb=0.26
X12 VGND.t4 a_507_47.t4 a_885_47.t0 VNB.t3 sky130_fd_pr__nfet_01v8 ad=0.25675 pd=1.44 as=0.26 ps=1.45 w=0.65 l=0.15 sa=4.89 sb=2.57
X13 a_507_47.t1 a_149_47.t4 a_341_297.t1 VPB.t3 sky130_fd_pr__pfet_01v8_hvt ad=0.26 pd=2.52 as=0.4 ps=1.8 w=1 l=0.15 sa=1.63 sb=0.26
X14 VPWR.t3 a_507_47.t5 a_1263_297.t2 VPB.t8 sky130_fd_pr__pfet_01v8_hvt ad=0.135 pd=1.27 as=0.4 ps=1.8 w=1 l=0.15 sa=1.21 sb=0.68
X15 a_149_47.t2 A.t3 a_149_297.t1 VPB.t4 sky130_fd_pr__pfet_01v8_hvt ad=0.26 pd=2.52 as=0.135 ps=1.27 w=1 l=0.15 sa=0.68 sb=0.26
X16 a_885_47.t2 a_507_47.t6 a_885_297.t1 VPB.t9 sky130_fd_pr__pfet_01v8_hvt ad=0.26 pd=2.52 as=0.4 ps=1.8 w=1 l=0.15 sa=1.21 sb=0.26
X17 a_507_47.t2 A.t0 a_423_47.t1 VNB.t5 sky130_fd_pr__nfet_01v8 ad=0.26 pd=1.45 as=0.08775 ps=0.92 w=0.65 l=0.15 sa=2.05 sb=5.41
X18 a_149_297.t0 B.t3 VPWR.t0 VPB.t0 sky130_fd_pr__pfet_01v8_hvt ad=0.135 pd=1.27 as=0.26 ps=2.52 w=1 l=0.15 sa=0.26 sb=0.68
X19 a_885_297.t0 C.t3 VPWR.t5 VPB.t6 sky130_fd_pr__pfet_01v8_hvt ad=0.4 pd=1.8 as=0.26 ps=2.52 w=1 l=0.15 sa=0.26 sb=1.21
R0 VGND.n1 VGND.n0 9.3005
R1 VGND.n3 VGND.n2 9.3005
R2 VGND.n5 VGND.n4 9.3005
R3 VGND.n7 VGND.n6 9.3005
R4 VGND.n9 VGND.n8 9.3005
R5 VGND.n11 VGND.n10 9.3005
R6 VGND.n13 VGND.n12 9.3005
R7 VGND.n15 VGND.n14 9.3005
R8 VGND.n17 VGND.n16 9.3005
R9 VGND.n19 VGND.n18 9.3005
R10 VGND.n21 VGND.n20 9.3005
R11 VGND.n23 VGND.n22 9.3005
R12 VGND VGND.n32 0.0226354
R13 VGND.n32 VGND.n1 0.120292
R14 VGND.n1 VGND.n3 0.120292
R15 VGND.n3 VGND.n5 0.120292
R16 VGND.n5 VGND.n7 0.120292
R17 VGND.n7 VGND.n9 0.120292
R18 VGND.n9 VGND.n11 0.120292
R19 VGND.n11 VGND.n13 0.120292
R20 VGND.n13 VGND.n15 0.120292
R21 VGND.n15 VGND.n17 0.120292
R22 VGND.n17 VGND.n19 0.120292
R23 VGND.n19 VGND.n21 0.120292
R24 VGND.n21 VGND.n23 0.120292
R25 VGND.n23 VGND.n24 0.174159
R26 VGND.n24 VGND.t6 173.409
R27 VGND.n32 VGND.n31 26.6181
R28 VGND.n31 VGND.n0 17.3181
R29 VGND.n0 VGND.n2 34.6358
R30 VGND.n2 VGND.n30 31.2476
R31 VGND.n4 VGND.n30 3.38874
R32 VGND.n4 VGND.n6 34.6358
R33 VGND.n6 VGND.n8 34.6358
R34 VGND.n8 VGND.n10 34.6358
R35 VGND.n10 VGND.n12 34.6358
R36 VGND.n12 VGND.n28 32.377
R37 VGND.n14 VGND.n28 2.25932
R38 VGND.n14 VGND.n16 34.6358
R39 VGND.n16 VGND.n18 34.6358
R40 VGND.n18 VGND.n20 34.6358
R41 VGND.n20 VGND.n22 34.6358
R42 VGND.n22 VGND.n26 1.50638
R43 VGND.n26 VGND.n24 40.7036
R44 VGND.n31 VGND.t2 160.222
R45 VGND.n30 VGND.n29 207.213
R46 VGND.n29 VGND.t1 73.8467
R47 VGND.n29 VGND.t3 73.8467
R48 VGND.n28 VGND.n27 207.213
R49 VGND.n27 VGND.t0 72.9236
R50 VGND.n27 VGND.t7 72.9236
R51 VGND.n26 VGND.n25 207.213
R52 VGND.n25 VGND.t4 72.9236
R53 VGND.n25 VGND.t5 72.9236
R54 Y.n1 Y.n0 185
R55 Y.n0 Y 194.892
R56 Y Y.n1 3.29747
R57 Y.n2 Y.n1 21.1902
R58 Y Y.n2 0.376971
R59 Y.n2 Y.t0 837.274
R60 Y.n0 Y.t1 73.8467
R61 Y.n0 Y.t2 73.8467
R62 VPWR.n2 VPWR.n1 9.3005
R63 VPWR.n4 VPWR.n3 9.3005
R64 VPWR.n6 VPWR.n5 9.3005
R65 VPWR.n8 VPWR.n7 9.3005
R66 VPWR.n10 VPWR.n9 9.3005
R67 VPWR.n12 VPWR.n11 9.3005
R68 VPWR.n14 VPWR.n13 9.3005
R69 VPWR.n16 VPWR.n15 9.3005
R70 VPWR VPWR.n0 0.0226354
R71 VPWR.n0 VPWR.n2 0.120292
R72 VPWR.n2 VPWR.n4 0.120292
R73 VPWR.n4 VPWR.n6 0.120292
R74 VPWR.n6 VPWR.n8 0.120292
R75 VPWR.n8 VPWR.n10 0.120292
R76 VPWR.n10 VPWR.n12 0.120292
R77 VPWR.n12 VPWR.n14 0.120292
R78 VPWR.n14 VPWR.n16 0.120292
R79 VPWR.n16 VPWR.n17 0.147321
R80 VPWR.n17 VPWR.n22 620.23
R81 VPWR.n0 VPWR.n18 26.6181
R82 VPWR.n18 VPWR.n1 17.3181
R83 VPWR.n1 VPWR.n3 34.6358
R84 VPWR.n3 VPWR.n5 34.6358
R85 VPWR.n5 VPWR.n7 34.6358
R86 VPWR.n7 VPWR.n20 13.5534
R87 VPWR.n20 VPWR.n9 21.0829
R88 VPWR.n9 VPWR.n11 34.6358
R89 VPWR.n11 VPWR.n13 34.6358
R90 VPWR.n13 VPWR.n15 34.6358
R91 VPWR.n15 VPWR.n21 17.3181
R92 VPWR.n17 VPWR.n21 24.9186
R93 VPWR.n22 VPWR.t3 26.5955
R94 VPWR.n22 VPWR.t4 26.5955
R95 VPWR.n21 VPWR.t5 876.193
R96 VPWR.n20 VPWR.n19 607.212
R97 VPWR.n19 VPWR.t2 26.5955
R98 VPWR.n19 VPWR.t1 26.5955
R99 VPWR.n18 VPWR.t0 257.474
R100 C.n1 C.n0 152
R101 C C.n1 6.4005
R102 C.n3 C.n1 26.3088
R103 C C.n3 0.376971
R104 C.n3 C.n2 158.024
R105 C.n2 C.t0 158.064
R106 C.n2 C.t2 230.363
R107 C.n0 C.t1 158.064
R108 C.n0 C.t3 230.363
R109 A.n1 A.n0 152
R110 A A.n1 6.4005
R111 A A.n1 122.353
R112 A A.n2 158.4
R113 A.n2 A.t0 158.064
R114 A.n2 A.t2 230.363
R115 A.n0 A.t1 158.064
R116 A.n0 A.t3 230.363
R117 B.n1 B.n0 152
R118 B B.n1 6.4005
R119 B.n3 B.n1 25.2816
R120 B B.n3 0.376971
R121 B.n3 B.n2 158.024
R122 B.n2 B.t0 158.064
R123 B.n2 B.t2 230.363
R124 B.n0 B.t1 158.064
R125 B.n0 B.t3 230.363
R126 VPB VPB.t0 310.748
R127 VPB.t0 VPB.t4 248.599
R128 VPB.t4 VPB.t1 562.306
R129 VPB.t1 VPB.t5 248.599
R130 VPB.t5 VPB.t3 562.306
R131 VPB.t3 VPB.t6 556.386
R132 VPB.t6 VPB.t9 562.306
R133 VPB.t9 VPB.t2 556.386
R134 VPB.t2 VPB.t8 562.306
R135 VPB.t8 VPB.t7 248.599
R136 VNB VNB.t1 1495.15
R137 VNB.t1 VNB.t4 1196.12
R138 VNB.t4 VNB.t2 2705.5
R139 VNB.t2 VNB.t5 1196.12
R140 VNB.t5 VNB.t0 2705.5
R141 VNB.t0 VNB.t6 2677.02
R142 VNB.t6 VNB.t3 2705.5
R143 VNB.t3 VNB.t8 2677.02
R144 VNB.t8 VNB.t9 2705.5
R145 VNB.t9 VNB.t7 1196.12
R146 a_1453_47.t0 a_1453_47.t1 49.8467
R147 a_423_47.t0 a_423_47.t1 49.8467
R148 a_1263_297.t0 a_1263_297.n0 78.8005
R149 a_1263_297.n0 a_1263_297.t2 78.8005
R150 a_1263_297.n0 a_1263_297.t1 897.418
R151 a_885_297.t0 a_885_297.t1 157.601
R152 a_341_297.t0 a_341_297.n0 694.521
R153 a_341_297.n0 a_341_297.t2 78.8005
R154 a_341_297.n0 a_341_297.t1 78.8005
R155 a_149_297.t0 a_149_297.t1 53.1905
R156 a_885_47.t2 a_885_47.n1 859.394
R157 a_885_47.n1 a_885_47.n2 217.882
R158 a_885_47.n2 a_885_47.t3 158.064
R159 a_885_47.n2 a_885_47.t4 230.363
R160 a_885_47.n1 a_885_47.n0 162.488
R161 a_885_47.n0 a_885_47.t1 73.8467
R162 a_885_47.n0 a_885_47.t0 73.8467
R163 a_507_47.t1 a_507_47.n3 228.773
R164 a_507_47.n3 a_507_47.n4 196.279
R165 a_507_47.n4 a_507_47.t2 73.8467
R166 a_507_47.n4 a_507_47.t0 73.8467
R167 a_507_47.n3 a_507_47.n2 91.1064
R168 a_507_47.n2 a_507_47.n1 348.05
R169 a_507_47.n1 a_507_47.t3 158.064
R170 a_507_47.n1 a_507_47.t5 230.363
R171 a_507_47.n2 a_507_47.n0 180.144
R172 a_507_47.n0 a_507_47.t4 158.064
R173 a_507_47.n0 a_507_47.t6 230.363
R174 a_149_47.t2 a_149_47.n0 218.792
R175 a_149_47.n0 a_149_47.n2 320.096
R176 a_149_47.n2 a_149_47.t3 158.064
R177 a_149_47.n2 a_149_47.t4 230.363
R178 a_149_47.n0 a_149_47.n1 209.135
R179 a_149_47.n1 a_149_47.t0 24.9236
R180 a_149_47.n1 a_149_47.t1 24.9236
C0 VPWR A 0.03216f
C1 VPB A 0.07947f
C2 VPWR VGND 0.03652f
C3 VPB VGND 0.01947f
C4 Y A 0.00302f
C5 Y VGND 0.17535f
C6 VGND A 0.08651f
C7 VPWR B 0.07994f
C8 VPWR C 0.06063f
C9 VPB B 0.08482f
C10 VPB C 0.08989f
C11 Y B 0.00333f
C12 Y C 0.2271f
C13 B A 0.14346f
C14 VPB VPWR 0.25112f
C15 VGND B 0.09153f
C16 VGND C 0.08213f
C17 VPWR Y 0.05567f
C18 VPB Y 0.01875f
C19 VGND VNB 0.02567f
C20 Y VNB 0f
C21 VPWR VNB 0f
C22 C VNB 0f
C23 A VNB 0.02802f
C24 B VNB 0f
C25 VPB VNB 0.95338f
C26 a_149_47.t2 VNB 0.1126f
C27 a_149_47.n0 VNB 0.26532f
C28 a_149_47.n1 VNB 0.09087f
C29 a_149_47.t0 VNB 0.03577f
C30 a_149_47.t1 VNB 0.03625f
C31 a_149_47.n2 VNB 0.12098f
C32 a_507_47.t1 VNB 0.10978f
C33 a_507_47.n0 VNB 0.07541f
C34 a_507_47.n1 VNB 0.12905f
C35 a_507_47.n2 VNB 0.20095f
C36 a_507_47.n3 VNB 0.21781f
C37 a_507_47.n4 VNB 0.13775f
C38 a_507_47.t2 VNB 0.06473f
C39 a_507_47.t0 VNB 0.06303f
C40 a_885_47.t2 VNB 0.094f
C41 a_885_47.n0 VNB 0.10444f
C42 a_885_47.t1 VNB 0.05969f
C43 a_885_47.t0 VNB 0.0559f
C44 a_885_47.n1 VNB 0.15024f
C45 a_885_47.n2 VNB 0.06983f
C46 a_149_297.t0 VNB 0.044f
C47 a_149_297.t1 VNB 0.04468f
C48 a_341_297.t0 VNB 0.11956f
C49 a_341_297.n0 VNB 0.1237f
C50 a_341_297.t2 VNB 0.06609f
C51 a_341_297.t1 VNB 0.06372f
C52 a_885_297.t0 VNB 0.07277f
C53 a_885_297.t1 VNB 0.06751f
C54 a_1263_297.t0 VNB 0.0568f
C55 a_1263_297.n0 VNB 0.09733f
C56 a_1263_297.t1 VNB 0.14358f
C57 a_1263_297.t2 VNB 0.0605f
C58 a_423_47.t0 VNB 0.0295f
C59 a_423_47.t1 VNB 0.02999f
C60 a_1453_47.t0 VNB 0.03286f
C61 a_1453_47.t1 VNB 0.02907f
C62 VPB.t0 VNB 0.04523f
C63 VPB.t1 VNB 0.06557f
C64 VPB.t2 VNB 0.09045f
C65 VPB.t3 VNB 0.09045f
C66 VPB.t4 VNB 0.06557f
C67 VPB.t5 VNB 0.06557f
C68 VPB.t6 VNB 0.09045f
C69 VPB.t7 VNB 0.10242f
C70 VPB.t8 VNB 0.06557f
C71 VPB.t9 VNB 0.09045f
C72 B.n0 VNB 0.07888f
C73 B.n1 VNB 0.06044f
C74 B.n2 VNB 0.07938f
C75 B.n3 VNB 0.09701f
C76 A.n0 VNB 0.08077f
C77 A.n1 VNB 0.06676f
C78 A.n2 VNB 0.08131f
C79 C.n0 VNB 0.08594f
C80 C.n1 VNB 0.13487f
C81 C.n2 VNB 0.08649f
C82 C.n3 VNB 0.2138f
C83 VPWR.n0 VNB 0.02594f
C84 VPWR.n1 VNB 0.009f
C85 VPWR.n2 VNB 0.03389f
C86 VPWR.n3 VNB 0.012f
C87 VPWR.n4 VNB 0.03389f
C88 VPWR.n5 VNB 0.012f
C89 VPWR.n6 VNB 0.03389f
C90 VPWR.n7 VNB 0.00835f
C91 VPWR.n8 VNB 0.03389f
C92 VPWR.n9 VNB 0.00966f
C93 VPWR.n10 VNB 0.03389f
C94 VPWR.n11 VNB 0.012f
C95 VPWR.n12 VNB 0.03389f
C96 VPWR.n13 VNB 0.012f
C97 VPWR.n14 VNB 0.03389f
C98 VPWR.n15 VNB 0.009f
C99 VPWR.n16 VNB 0.0418f
C100 VPWR.n17 VNB 0.40952f
C101 VPWR.t0 VNB 0.06869f
C102 VPWR.n18 VNB 0.03831f
C103 VPWR.t2 VNB 0.03855f
C104 VPWR.t1 VNB 0.03923f
C105 VPWR.n19 VNB 0.02102f
C106 VPWR.n20 VNB 0.01771f
C107 VPWR.t5 VNB 0.06688f
C108 VPWR.n21 VNB 0.0253f
C109 VPWR.t3 VNB 0.03582f
C110 VPWR.t4 VNB 0.04108f
C111 VPWR.n22 VNB 0.02181f
C112 Y.n0 VNB 0.09173f
C113 Y.t1 VNB 0.06095f
C114 Y.t2 VNB 0.06362f
C115 Y.n1 VNB 0.22602f
C116 Y.t0 VNB 0.10336f
C117 Y.n2 VNB 0.23524f
C118 VGND.n0 VNB 0.00631f
C119 VGND.n1 VNB 0.02377f
C120 VGND.n2 VNB 0.00801f
C121 VGND.n3 VNB 0.02377f
C122 VGND.n4 VNB 0.00462f
C123 VGND.n5 VNB 0.02377f
C124 VGND.n6 VNB 0.00842f
C125 VGND.n7 VNB 0.02377f
C126 VGND.n8 VNB 0.00842f
C127 VGND.n9 VNB 0.02377f
C128 VGND.n10 VNB 0.00842f
C129 VGND.n11 VNB 0.02377f
C130 VGND.n12 VNB 0.00814f
C131 VGND.n13 VNB 0.02377f
C132 VGND.n14 VNB 0.00448f
C133 VGND.n15 VNB 0.02377f
C134 VGND.n16 VNB 0.00842f
C135 VGND.n17 VNB 0.02377f
C136 VGND.n18 VNB 0.00842f
C137 VGND.n19 VNB 0.02377f
C138 VGND.n20 VNB 0.00842f
C139 VGND.n21 VNB 0.02377f
C140 VGND.n22 VNB 0.00439f
C141 VGND.n23 VNB 0.04755f
C142 VGND.n24 VNB 0.14887f
C143 VGND.t6 VNB 0.04124f
C144 VGND.t4 VNB 0.03219f
C145 VGND.t5 VNB 0.02952f
C146 VGND.n25 VNB 0.02825f
C147 VGND.n26 VNB 0.01387f
C148 VGND.t0 VNB 0.03294f
C149 VGND.t7 VNB 0.03599f
C150 VGND.n27 VNB 0.02825f
C151 VGND.n28 VNB 0.01201f
C152 VGND.t1 VNB 0.03482f
C153 VGND.t3 VNB 0.03434f
C154 VGND.n29 VNB 0.0286f
C155 VGND.n30 VNB 0.01201f
C156 VGND.t2 VNB 0.03738f
C157 VGND.n31 VNB 0.02221f
C158 VGND.n32 VNB 0.01819f
.ends
