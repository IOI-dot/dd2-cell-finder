* NGSPICE file created from dd2_ref__inv_1.ext - technology: sky130A

.subckt dd2_ref__inv_1 A Y VGND VPWR VPB VNB
X0 Y A VPWR VPB sky130_fd_pr__pfet_01v8_hvt ad=0.26 pd=2.52 as=0.26 ps=2.52 w=1 l=0.15
X1 Y A VGND VNB sky130_fd_pr__nfet_01v8 ad=0.169 pd=1.82 as=0.169 ps=1.82 w=0.65 l=0.15
C0 VPB A 0.044f
C1 VPWR VGND 0.0185f
C2 VPB VGND 0.0133f
C3 VPB VPWR 0.06749f
C4 Y A 0.03493f
C5 Y VGND 0.05944f
C6 VGND A 0.03465f
C7 Y VPWR 0.0738f
C8 VPB Y 0.01774f
C9 VPWR A 0.0345f
C10 VGND VNB 0.24423f
C11 Y VNB 0.16223f
C12 VPWR VNB 0.26946f
C13 VPB VNB 0.33898f
.ends
