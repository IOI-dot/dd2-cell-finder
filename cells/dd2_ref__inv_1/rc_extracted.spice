* NGSPICE file created from dd2_ref__inv_1.ext - technology: sky130A

.subckt dd2_ref__inv_1 A VGND VNB VPB VPWR Y
X0 Y.t0 A.t1 VPWR.t0 VPB.t0 sky130_fd_pr__pfet_01v8_hvt ad=0.26 pd=2.52 as=0.26 ps=2.52 w=1 l=0.15 sa=0.26 sb=0.26
X1 Y.t1 A.t0 VGND.t0 VNB.t0 sky130_fd_pr__nfet_01v8 ad=0.169 pd=1.82 as=0.169 ps=1.82 w=0.65 l=0.15 sa=0.26 sb=0.26
R0 VGND VGND.t0 173.082
R1 Y Y.n1 7.09462
R2 Y.n0 Y.t0 218.236
R3 Y.n0 Y.n1 75.8133
R4 Y Y.n0 7.7871
R5 Y.n1 Y.t1 129.369
R6 VPWR VPWR.t0 270.332
R7 A A.n0 158.4
R8 A.n0 A.t0 169.237
R9 A.n0 A.t1 241.536
R10 VPB VPB.t0 350.853
R11 VNB VNB.t0 1612.5
C0 Y VGND 0.064f
C1 A VPB 0.03953f
C2 VPWR VGND 0.02036f
C3 VPWR Y 0.08008f
C4 A VGND 0.02437f
C5 VPB VGND 0.01128f
C6 A Y 0.03877f
C7 VPB Y 0.0213f
C8 VPWR A 0.02603f
C9 VPWR VPB 0.06439f
C10 VGND VNB 0.31642f
C11 Y VNB 0f
C12 VPWR VNB 0.29882f
C13 A VNB 0.09036f
C14 VPB VNB 0.30453f
C15 VPB.t0 VNB 0.08547f
C16 A.n0 VNB 0.04207f
C17 VPWR.t0 VNB 0.05996f
C18 Y.n0 VNB 0.04752f
C19 Y.n1 VNB 0.04348f
C20 Y.t1 VNB 0.03776f
C21 Y.t0 VNB 0.06159f
C22 VGND.t0 VNB 0.03258f
.ends
