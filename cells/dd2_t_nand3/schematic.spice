.subckt dd2_t_nand3 A B C VGND VNB VPB VPWR Y
X0 Y A n1 VNB sky130_fd_pr__nfet_01v8 w=650000u l=150000u
X1 n1 B n2 VNB sky130_fd_pr__nfet_01v8 w=650000u l=150000u
X2 n2 C VGND VNB sky130_fd_pr__nfet_01v8 w=650000u l=150000u
X3 Y A VPWR VPB sky130_fd_pr__pfet_01v8_hvt w=1000000u l=150000u
X4 Y B VPWR VPB sky130_fd_pr__pfet_01v8_hvt w=1000000u l=150000u
X5 Y C VPWR VPB sky130_fd_pr__pfet_01v8_hvt w=1000000u l=150000u
.ends
