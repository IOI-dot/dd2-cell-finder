* NGSPICE file created from dd2_g4__n3_9f_1.ext - technology: sky130A

.subckt dd2_g4__n3_9f_1 A B C VGND VNB VPB VPWR Y
X0 VPWR.t4 a_91_21.t4 Y.t3 VPB.t0 sky130_fd_pr__pfet_01v8_hvt ad=0.235 pd=1.47 as=0.26 ps=2.52 w=1 l=0.15 sa=0.26 sb=3.34
X1 a_245_47.t2 C.t0 a_121_47.t1 VNB.t5 sky130_fd_pr__nfet_01v8 ad=0.08775 pd=0.92 as=0.15275 ps=1.12 w=0.65 l=0.15 sa=0.88 sb=1.16
X2 a_245_47.t0 B.t1 VGND.t1 VNB.t1 sky130_fd_pr__nfet_01v8 ad=0.169 pd=1.82 as=0.10725 ps=0.98 w=0.65 l=0.15 sa=1.78 sb=0.26
X3 VPWR.t1 B.t3 a_329_297.t0 VPB.t1 sky130_fd_pr__pfet_01v8_hvt ad=0.395 pd=1.79 as=0.165 ps=1.33 w=1 l=0.15 sa=1.78 sb=1.82
X4 a_329_297.t1 A.t3 Y.t0 VPB.t3 sky130_fd_pr__pfet_01v8_hvt ad=0.165 pd=1.33 as=0.135 ps=1.27 w=1 l=0.15 sa=1.3 sb=2.3
X5 VGND.t2 A.t1 a_245_47.t1 VNB.t3 sky130_fd_pr__nfet_01v8 ad=0.10725 pd=0.98 as=0.08775 ps=0.92 w=0.65 l=0.15 sa=1.3 sb=0.74
X6 a_121_47.t0 a_91_21.t3 Y.t2 VNB.t0 sky130_fd_pr__nfet_01v8 ad=0.15275 pd=1.12 as=0.169 ps=1.82 w=0.65 l=0.15 sa=0.26 sb=1.78
X7 a_91_21.t2 A.t0 a_613_47.t1 VNB.t4 sky130_fd_pr__nfet_01v8 ad=0.169 pd=1.82 as=0.15275 ps=1.12 w=0.65 l=0.15 sa=0.88 sb=0.26
X8 a_91_21.t0 B.t2 VPWR.t0 VPB.t2 sky130_fd_pr__pfet_01v8_hvt ad=0.235 pd=1.47 as=0.395 ps=1.79 w=1 l=0.15 sa=2.72 sb=0.88
X9 Y.t1 C.t1 VPWR.t2 VPB.t5 sky130_fd_pr__pfet_01v8_hvt ad=0.135 pd=1.27 as=0.235 ps=1.47 w=1 l=0.15 sa=0.88 sb=2.72
X10 a_613_47.t0 B.t0 VGND.t0 VNB.t2 sky130_fd_pr__nfet_01v8 ad=0.15275 pd=1.12 as=0.169 ps=1.82 w=0.65 l=0.15 sa=0.26 sb=0.88
X11 VPWR.t3 A.t2 a_91_21.t1 VPB.t4 sky130_fd_pr__pfet_01v8_hvt ad=0.26 pd=2.52 as=0.235 ps=1.47 w=1 l=0.15 sa=3.34 sb=0.26
R0 VGND VGND.n0 0.7798
R1 VGND.n0 VGND.t0 302.57
R2 VGND.n0 VGND.n1 219.184
R3 VGND.n1 VGND.t2 30.462
R4 VGND.n1 VGND.t1 30.462
R5 VPWR.n2 VPWR.n1 9.3005
R6 VPWR.n4 VPWR.n3 9.3005
R7 VPWR.n6 VPWR.n5 9.3005
R8 VPWR VPWR.n0 0.121778
R9 VPWR.n0 VPWR.n2 0.141672
R10 VPWR.n2 VPWR.n4 0.120292
R11 VPWR.n4 VPWR.n6 0.120292
R12 VPWR.n6 VPWR.n7 0.237643
R13 VPWR.n7 VPWR.t3 358.8
R14 VPWR.n0 VPWR.n9 18.9532
R15 VPWR.n9 VPWR.n1 23.3417
R16 VPWR.n1 VPWR.n3 34.6358
R17 VPWR.n3 VPWR.n5 34.6358
R18 VPWR.n5 VPWR.n11 33.8829
R19 VPWR.n7 VPWR.n11 8.26366
R20 VPWR.n11 VPWR.n10 320.976
R21 VPWR.n10 VPWR.t1 77.8155
R22 VPWR.n10 VPWR.t0 77.8155
R23 VPWR.n9 VPWR.n8 607.212
R24 VPWR.n8 VPWR.t4 46.2955
R25 VPWR.n8 VPWR.t2 46.2955
R26 Y Y.n0 8.14432
R27 Y.n1 Y.n2 585
R28 Y.n4 Y.n0 88.2305
R29 Y.n2 Y.n4 2.5605
R30 Y Y.n2 8.1605
R31 Y Y.n1 587.721
R32 Y.n4 Y.n3 358.245
R33 Y.n3 Y.t1 26.5955
R34 Y.n3 Y.t0 26.5955
R35 Y.n1 Y.t3 26.5955
R36 Y.n0 Y.t2 129.028
R37 B.n0 B.n1 137.298
R38 B B.n0 167.165
R39 B.n1 B.t3 212.081
R40 B.n1 B.t1 139.78
R41 B.n0 B.t2 212.081
R42 B.n0 B.t0 139.78
R43 A.n1 A.n0 152
R44 A A.n1 6.4005
R45 A.n3 A.n1 164.142
R46 A A.n3 0.376971
R47 A.n3 A.n2 158.024
R48 A.n2 A.t0 169.237
R49 A.n2 A.t2 241.536
R50 A.n0 A.t1 169.237
R51 A.n0 A.t3 241.536
R52 C C.n0 158.4
R53 C.n0 C.t0 169.237
R54 C.n0 C.t1 241.536
R55 VPB VPB.t0 227.882
R56 VPB.t0 VPB.t5 366.978
R57 VPB.t5 VPB.t3 248.599
R58 VPB.t3 VPB.t1 284.113
R59 VPB.t1 VPB.t2 556.386
R60 VPB.t2 VPB.t4 366.978
R61 VNB VNB.t0 1096.44
R62 VNB.t0 VNB.t5 1765.7
R63 VNB.t5 VNB.t3 1196.12
R64 VNB.t3 VNB.t1 1366.99
R65 VNB.t1 VNB.t2 2677.02
R66 VNB.t2 VNB.t4 1765.7
R67 a_613_47.t0 a_613_47.t1 86.7697
R68 a_245_47.t0 a_245_47.n0 444.024
R69 a_245_47.n0 a_245_47.t2 24.9236
R70 a_245_47.n0 a_245_47.t1 24.9236
R71 a_121_47.t0 a_121_47.t1 86.7697
R72 a_329_297.t0 a_329_297.t1 65.0105
R73 a_91_21.n0 a_91_21.n2 205.28
R74 a_91_21.t0 a_91_21.n0 46.2955
R75 a_91_21.n0 a_91_21.t1 46.2955
R76 a_91_21.n2 a_91_21.n1 359.721
R77 a_91_21.n1 a_91_21.t3 169.237
R78 a_91_21.n1 a_91_21.t4 241.536
R79 a_91_21.n2 a_91_21.t2 394.949
C0 VPB VPWR 0.12542f
C1 B VGND 0.03714f
C2 Y B 0.00315f
C3 A VGND 0.068f
C4 Y A 0.00815f
C5 C A 0.03221f
C6 VPB VGND 0.00838f
C7 VPB Y 0.01687f
C8 VPWR VGND 0.0471f
C9 Y VPWR 0.13099f
C10 C VPB 0.02852f
C11 C VPWR 0.01436f
C12 B A 0.12168f
C13 Y VGND 0.03694f
C14 VPB B 0.09564f
C15 VPB A 0.06319f
C16 B VPWR 0.04058f
C17 A VPWR 0.03765f
C18 C VGND 0.01676f
C19 C Y 0.01551f
C20 VGND VNB 0.39686f
C21 VPWR VNB 0f
C22 Y VNB 0f
C23 B VNB 0.00859f
C24 A VNB 0f
C25 C VNB 0.0258f
C26 VPB VNB 0.56451f
C27 a_91_21.t0 VNB 0.05708f
C28 a_91_21.n0 VNB 0.07071f
C29 a_91_21.t2 VNB 0.08285f
C30 a_91_21.n1 VNB 0.09194f
C31 a_91_21.n2 VNB 0.26967f
C32 a_91_21.t1 VNB 0.06281f
C33 a_329_297.t0 VNB 0.04084f
C34 a_329_297.t1 VNB 0.04657f
C35 a_121_47.t0 VNB 0.03376f
C36 a_121_47.t1 VNB 0.03756f
C37 a_245_47.t0 VNB 0.09362f
C38 a_245_47.n0 VNB 0.11135f
C39 a_245_47.t2 VNB 0.03195f
C40 a_245_47.t1 VNB 0.03376f
C41 a_613_47.t0 VNB 0.03274f
C42 a_613_47.t1 VNB 0.03742f
C43 VPB.t0 VNB 0.04438f
C44 VPB.t1 VNB 0.06271f
C45 VPB.t2 VNB 0.06889f
C46 VPB.t3 VNB 0.03975f
C47 VPB.t4 VNB 0.09097f
C48 VPB.t5 VNB 0.04593f
C49 C.n0 VNB 0.05446f
C50 A.n0 VNB 0.05897f
C51 A.n1 VNB 0.08027f
C52 A.n2 VNB 0.05948f
C53 A.n3 VNB 0.09785f
C54 B.n0 VNB 0.09885f
C55 B.n1 VNB 0.0863f
C56 Y.n0 VNB 0.04705f
C57 Y.t2 VNB 0.04264f
C58 Y.n1 VNB 0.03941f
C59 Y.t3 VNB 0.03549f
C60 Y.n2 VNB 0.0137f
C61 Y.n3 VNB 0.03615f
C62 Y.t1 VNB 0.04075f
C63 Y.t0 VNB 0.04325f
C64 Y.n4 VNB 0.08397f
C65 VPWR.n0 VNB 0.03418f
C66 VPWR.n1 VNB 0.0085f
C67 VPWR.n2 VNB 0.03301f
C68 VPWR.n3 VNB 0.01015f
C69 VPWR.n4 VNB 0.02867f
C70 VPWR.n5 VNB 0.01004f
C71 VPWR.n6 VNB 0.07752f
C72 VPWR.n7 VNB 0.11242f
C73 VPWR.t4 VNB 0.03694f
C74 VPWR.t2 VNB 0.04221f
C75 VPWR.n8 VNB 0.03076f
C76 VPWR.n9 VNB 0.01857f
C77 VPWR.n10 VNB 0.05257f
C78 VPWR.t1 VNB 0.04936f
C79 VPWR.t0 VNB 0.04936f
C80 VPWR.n11 VNB 0.02791f
C81 VPWR.t3 VNB 0.06345f
C82 VGND.n0 VNB 0.17725f
C83 VGND.t0 VNB 0.03737f
C84 VGND.t2 VNB 0.0281f
C85 VGND.t1 VNB 0.02342f
C86 VGND.n1 VNB 0.0154f
.ends
