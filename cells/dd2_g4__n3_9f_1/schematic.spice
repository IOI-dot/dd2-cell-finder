.subckt dd2_g4__n3_9f_1 A B C VGND VNB VPB VPWR Y
X0 _s1 A n1 VNB sky130_fd_pr__nfet_01v8 w=650000u l=150000u
X1 n1 B VGND VNB sky130_fd_pr__nfet_01v8 w=650000u l=150000u
X2 Y _s1 n2 VNB sky130_fd_pr__nfet_01v8 w=650000u l=150000u
X3 n2 C n3 VNB sky130_fd_pr__nfet_01v8 w=650000u l=150000u
X4 n3 A VGND VNB sky130_fd_pr__nfet_01v8 w=650000u l=150000u
X5 n3 B VGND VNB sky130_fd_pr__nfet_01v8 w=650000u l=150000u
X6 _s1 A VPWR VPB sky130_fd_pr__pfet_01v8_hvt w=1000000u l=150000u
X7 _s1 B VPWR VPB sky130_fd_pr__pfet_01v8_hvt w=1000000u l=150000u
X8 Y _s1 VPWR VPB sky130_fd_pr__pfet_01v8_hvt w=1000000u l=150000u
X9 Y C VPWR VPB sky130_fd_pr__pfet_01v8_hvt w=1000000u l=150000u
X10 Y A p1 VPB sky130_fd_pr__pfet_01v8_hvt w=1000000u l=150000u
X11 p1 B VPWR VPB sky130_fd_pr__pfet_01v8_hvt w=1000000u l=150000u
.ends
