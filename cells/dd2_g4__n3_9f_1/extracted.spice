* NGSPICE file created from dd2_g4__n3_9f_1.ext - technology: sky130A

.subckt dd2_g4__n3_9f_1 A B C VGND VNB VPB VPWR Y
X0 VPWR a_91_21# Y VPB sky130_fd_pr__pfet_01v8_hvt ad=0.235 pd=1.47 as=0.26 ps=2.52 w=1 l=0.15
X1 a_245_47# C a_121_47# VNB sky130_fd_pr__nfet_01v8 ad=0.08775 pd=0.92 as=0.15275 ps=1.12 w=0.65 l=0.15
X2 a_245_47# B VGND VNB sky130_fd_pr__nfet_01v8 ad=0.169 pd=1.82 as=0.10725 ps=0.98 w=0.65 l=0.15
X3 VPWR B a_329_297# VPB sky130_fd_pr__pfet_01v8_hvt ad=0.395 pd=1.79 as=0.165 ps=1.33 w=1 l=0.15
X4 a_329_297# A Y VPB sky130_fd_pr__pfet_01v8_hvt ad=0.165 pd=1.33 as=0.135 ps=1.27 w=1 l=0.15
X5 VGND A a_245_47# VNB sky130_fd_pr__nfet_01v8 ad=0.10725 pd=0.98 as=0.08775 ps=0.92 w=0.65 l=0.15
X6 a_121_47# a_91_21# Y VNB sky130_fd_pr__nfet_01v8 ad=0.15275 pd=1.12 as=0.169 ps=1.82 w=0.65 l=0.15
X7 a_91_21# A a_613_47# VNB sky130_fd_pr__nfet_01v8 ad=0.169 pd=1.82 as=0.15275 ps=1.12 w=0.65 l=0.15
X8 a_91_21# B VPWR VPB sky130_fd_pr__pfet_01v8_hvt ad=0.235 pd=1.47 as=0.395 ps=1.79 w=1 l=0.15
X9 Y C VPWR VPB sky130_fd_pr__pfet_01v8_hvt ad=0.135 pd=1.27 as=0.235 ps=1.47 w=1 l=0.15
X10 a_613_47# B VGND VNB sky130_fd_pr__nfet_01v8 ad=0.15275 pd=1.12 as=0.169 ps=1.82 w=0.65 l=0.15
X11 VPWR A a_91_21# VPB sky130_fd_pr__pfet_01v8_hvt ad=0.26 pd=2.52 as=0.235 ps=1.47 w=1 l=0.15
.ends
