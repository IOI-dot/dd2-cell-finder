* NGSPICE file created from dd2_ref__nand2_1.ext - technology: sky130A

.subckt dd2_ref__nand2_1 A B VGND VNB VPB VPWR Y
X0 VPWR A Y VPB sky130_fd_pr__pfet_01v8_hvt ad=0.26 pd=2.52 as=0.135 ps=1.27 w=1 l=0.15
X1 Y A a_109_47# VNB sky130_fd_pr__nfet_01v8 ad=0.169 pd=1.82 as=0.08775 ps=0.92 w=0.65 l=0.15
X2 Y B VPWR VPB sky130_fd_pr__pfet_01v8_hvt ad=0.135 pd=1.27 as=0.26 ps=2.52 w=1 l=0.15
X3 a_109_47# B VGND VNB sky130_fd_pr__nfet_01v8 ad=0.08775 pd=0.92 as=0.169 ps=1.82 w=0.65 l=0.15
C0 Y B 0.03137f
C1 A VPB 0.03982f
C2 VGND B 0.0365f
C3 VPWR VPB 0.05912f
C4 Y VPB 0.0062f
C5 VPWR A 0.0346f
C6 Y A 0.06275f
C7 VPWR a_109_47# 0
C8 Y a_109_47# 0.00922f
C9 VGND VPB 0.00564f
C10 Y VPWR 0.11655f
C11 VGND A 0.01541f
C12 B VPB 0.03662f
C13 VGND a_109_47# 0.01033f
C14 VGND VPWR 0.01783f
C15 A B 0.02548f
C16 Y VGND 0.05471f
C17 VPWR B 0.03472f
C18 VGND VNB 0.23228f
C19 Y VNB 0.1653f
C20 VPWR VNB 0.34233f
C21 VPB VNB 0.33898f
.ends
