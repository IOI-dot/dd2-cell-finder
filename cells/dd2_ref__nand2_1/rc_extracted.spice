* NGSPICE file created from dd2_ref__nand2_1.ext - technology: sky130A

.subckt dd2_ref__nand2_1 B A Y VGND VPWR VPB VNB
X0 VPWR A Y VPB sky130_fd_pr__pfet_01v8_hvt ad=0.26 pd=2.52 as=0.135 ps=1.27 w=1 l=0.15
X1 Y A a_109_47# VNB sky130_fd_pr__nfet_01v8 ad=0.169 pd=1.82 as=0.08775 ps=0.92 w=0.65 l=0.15
X2 Y B VPWR VPB sky130_fd_pr__pfet_01v8_hvt ad=0.135 pd=1.27 as=0.26 ps=2.52 w=1 l=0.15
X3 a_109_47# B VGND VNB sky130_fd_pr__nfet_01v8 ad=0.08775 pd=0.92 as=0.169 ps=1.82 w=0.65 l=0.15
C0 Y a_109_47# 0.00922f
C1 VGND VPB 0.00564f
C2 Y VPWR 0.11655f
C3 VGND A 0.01541f
C4 B VPB 0.03662f
C5 VGND a_109_47# 0.01033f
C6 VGND VPWR 0.01783f
C7 A B 0.02548f
C8 Y VGND 0.05471f
C9 VPWR B 0.03472f
C10 Y B 0.03137f
C11 A VPB 0.03982f
C12 VGND B 0.0365f
C13 VPWR VPB 0.05912f
C14 Y VPB 0.0062f
C15 VPWR A 0.0346f
C16 Y A 0.06275f
C17 VPWR a_109_47# 0
C18 VGND VNB 0.23228f
C19 Y VNB 0.1653f
C20 VPWR VNB 0.34233f
C21 VPB VNB 0.33898f
.ends
