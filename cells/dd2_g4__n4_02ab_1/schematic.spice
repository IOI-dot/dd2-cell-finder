.subckt dd2_g4__n4_02ab_1 A B C D VGND VNB VPB VPWR Y
X0 _s1 A VGND VNB sky130_fd_pr__nfet_01v8 w=650000u l=150000u
X1 Y _s1 n1 VNB sky130_fd_pr__nfet_01v8 w=650000u l=150000u
X2 n1 D VGND VNB sky130_fd_pr__nfet_01v8 w=650000u l=150000u
X3 Y B n2 VNB sky130_fd_pr__nfet_01v8 w=650000u l=150000u
X4 Y C n2 VNB sky130_fd_pr__nfet_01v8 w=650000u l=150000u
X5 n2 _s1 VGND VNB sky130_fd_pr__nfet_01v8 w=650000u l=150000u
X6 n2 D VGND VNB sky130_fd_pr__nfet_01v8 w=650000u l=150000u
X7 _s1 A VPWR VPB sky130_fd_pr__pfet_01v8_hvt w=1000000u l=150000u
X8 Y _s1 p1 VPB sky130_fd_pr__pfet_01v8_hvt w=1000000u l=150000u
X9 Y D p1 VPB sky130_fd_pr__pfet_01v8_hvt w=1000000u l=150000u
X10 p1 B p2 VPB sky130_fd_pr__pfet_01v8_hvt w=1000000u l=150000u
X11 p2 C VPWR VPB sky130_fd_pr__pfet_01v8_hvt w=1000000u l=150000u
X12 p1 _s1 p3 VPB sky130_fd_pr__pfet_01v8_hvt w=1000000u l=150000u
X13 p3 D VPWR VPB sky130_fd_pr__pfet_01v8_hvt w=1000000u l=150000u
.ends
