* NGSPICE file created from dd2_g4__n4_02ab_1.ext - technology: sky130A

.subckt dd2_g4__n4_02ab_1 A B C D VGND VNB VPB VPWR Y
X0 a_354_297.t1 a_31_47.t5 a_270_297.t0 VPB.t2 sky130_fd_pr__pfet_01v8_hvt ad=0.3175 pd=1.635 as=0.135 ps=1.27 w=1 l=0.15 sa=1.465 sb=2.67
X1 a_270_297.t1 D.t3 VPWR.t2 VPB.t4 sky130_fd_pr__pfet_01v8_hvt ad=0.135 pd=1.27 as=0.3175 ps=1.635 w=1 l=0.15 sa=1.045 sb=3.09
X2 a_511_47.t1 D.t0 VGND.t0 VNB.t5 sky130_fd_pr__nfet_01v8 ad=0.08775 pd=0.92 as=0.20638 ps=1.285 w=0.65 l=0.15 sa=2.25 sb=1.885
X3 VGND.t3 a_31_47.t3 a_270_47.t1 VNB.t1 sky130_fd_pr__nfet_01v8 ad=0.20638 pd=1.285 as=0.08775 ps=0.92 w=0.65 l=0.15 sa=1.465 sb=2.67
X4 a_270_47.t2 B.t0 Y.t4 VNB.t3 sky130_fd_pr__nfet_01v8 ad=0.08775 pd=0.92 as=0.20638 ps=1.285 w=0.65 l=0.15 sa=3.455 sb=0.68
X5 VGND.t2 A.t0 a_31_47.t1 VNB.t6 sky130_fd_pr__nfet_01v8 ad=0.20638 pd=1.285 as=0.169 ps=1.82 w=0.65 l=0.15 sa=0.26 sb=3.875
X6 Y.t3 a_31_47.t2 a_511_47.t0 VNB.t2 sky130_fd_pr__nfet_01v8 ad=0.20638 pd=1.285 as=0.08775 ps=0.92 w=0.65 l=0.15 sa=2.67 sb=1.465
X7 VPWR.t1 C.t1 a_752_297.t0 VPB.t0 sky130_fd_pr__pfet_01v8_hvt ad=0.26 pd=2.52 as=0.135 ps=1.27 w=1 l=0.15 sa=3.875 sb=0.26
X8 a_752_297.t1 B.t1 a_354_297.t2 VPB.t3 sky130_fd_pr__pfet_01v8_hvt ad=0.135 pd=1.27 as=0.3175 ps=1.635 w=1 l=0.15 sa=3.455 sb=0.68
X9 Y.t0 C.t0 a_270_47.t0 VNB.t0 sky130_fd_pr__nfet_01v8 ad=0.169 pd=1.82 as=0.08775 ps=0.92 w=0.65 l=0.15 sa=3.875 sb=0.26
X10 VPWR.t0 A.t1 a_31_47.t0 VPB.t6 sky130_fd_pr__pfet_01v8_hvt ad=0.3175 pd=1.635 as=0.26 ps=2.52 w=1 l=0.15 sa=0.26 sb=3.875
X11 a_354_297.t0 a_31_47.t4 Y.t2 VPB.t1 sky130_fd_pr__pfet_01v8_hvt ad=0.3175 pd=1.635 as=0.135 ps=1.27 w=1 l=0.15 sa=2.67 sb=1.465
X12 Y.t1 D.t2 a_354_297.t3 VPB.t5 sky130_fd_pr__pfet_01v8_hvt ad=0.135 pd=1.27 as=0.3175 ps=1.635 w=1 l=0.15 sa=2.25 sb=1.885
X13 a_270_47.t3 D.t1 VGND.t1 VNB.t4 sky130_fd_pr__nfet_01v8 ad=0.08775 pd=0.92 as=0.20638 ps=1.285 w=0.65 l=0.15 sa=1.045 sb=3.09
R0 VGND VGND.n0 0.304164
R1 VGND.n0 VGND.n1 214.593
R2 VGND.n0 VGND.n2 132.888
R3 VGND.n2 VGND.t2 59.0774
R4 VGND.n2 VGND.t1 58.1543
R5 VGND.n1 VGND.t3 58.1543
R6 VGND.n1 VGND.t0 59.0774
R7 Y.n0 Y.n1 185
R8 Y.n1 Y.n2 185
R9 Y.n0 Y 9.89141
R10 Y Y.n2 3.29747
R11 Y.n2 Y.n3 610.303
R12 Y.n3 Y.t1 26.5955
R13 Y.n3 Y.t2 26.5955
R14 Y.n1 Y.t3 59.0774
R15 Y.n1 Y.t4 58.1543
R16 Y Y.n0 77.177
R17 Y Y.t0 274.478
R18 VPWR VPWR.n0 0.197315
R19 VPWR.n0 VPWR.t1 268.252
R20 VPWR.n0 VPWR.n1 619.509
R21 VPWR.n1 VPWR.t0 63.0405
R22 VPWR.n1 VPWR.t2 62.0555
R23 C C.n0 158.4
R24 C.n0 C.t0 158.064
R25 C.n0 C.t1 230.363
R26 B B.n0 158.4
R27 B.n0 B.t0 169.237
R28 B.n0 B.t1 241.536
R29 D.n1 D.n0 152
R30 D D.n1 6.4005
R31 D.n3 D.n1 25.192
R32 D D.n3 0.376971
R33 D.n3 D.n2 158.024
R34 D.n2 D.t0 169.237
R35 D.n2 D.t2 241.536
R36 D.n0 D.t1 169.237
R37 D.n0 D.t3 241.536
R38 A A.n0 158.4
R39 A.n0 A.t0 158.064
R40 A.n0 A.t1 230.363
R41 VPB VPB.t6 204.207
R42 VPB.t6 VPB.t4 464.642
R43 VPB.t4 VPB.t2 248.599
R44 VPB.t2 VPB.t5 464.642
R45 VPB.t5 VPB.t1 248.599
R46 VPB.t1 VPB.t3 464.642
R47 VPB.t3 VPB.t0 248.599
R48 VNB VNB.t6 982.524
R49 VNB.t6 VNB.t4 2235.6
R50 VNB.t4 VNB.t1 1196.12
R51 VNB.t1 VNB.t5 2235.6
R52 VNB.t5 VNB.t2 1196.12
R53 VNB.t2 VNB.t3 2235.6
R54 VNB.t3 VNB.t0 1196.12
R55 a_511_47.t0 a_511_47.t1 49.8467
R56 a_270_47.n0 a_270_47.t2 24.9236
R57 a_270_47.t0 a_270_47.n0 24.9236
R58 a_270_47.n0 a_270_47.n1 308.418
R59 a_270_47.n1 a_270_47.t3 24.9236
R60 a_270_47.n1 a_270_47.t1 24.9236
R61 a_752_297.t0 a_752_297.t1 53.1905
R62 a_354_297.n0 a_354_297.n1 462.079
R63 a_354_297.t0 a_354_297.n0 63.0405
R64 a_354_297.n0 a_354_297.t2 62.0555
R65 a_354_297.n1 a_354_297.t1 62.0555
R66 a_354_297.n1 a_354_297.t3 63.0405
R67 a_270_297.t0 a_270_297.t1 53.1905
R68 a_31_47.t0 a_31_47.n3 228.773
R69 a_31_47.n3 a_31_47.t1 198.087
R70 a_31_47.n1 a_31_47.n0 152
R71 a_31_47.n3 a_31_47.n1 135.906
R72 a_31_47.n1 a_31_47.n2 268.329
R73 a_31_47.n2 a_31_47.t2 158.064
R74 a_31_47.n2 a_31_47.t4 230.363
R75 a_31_47.n0 a_31_47.t3 158.064
R76 a_31_47.n0 a_31_47.t5 230.363
C0 D VPWR 0.02188f
C1 VGND A 0.03027f
C2 B C 0.03088f
C3 VPWR A 0.01645f
C4 C VPB 0.03907f
C5 VGND C 0.01252f
C6 VPWR C 0.03741f
C7 B VPB 0.03292f
C8 D Y 0.02542f
C9 VGND B 0.00857f
C10 VPWR B 0.01837f
C11 VGND VPB 0.00668f
C12 VPWR VPB 0.13224f
C13 D A 0.02541f
C14 Y C 0.02604f
C15 VPWR VGND 0.01815f
C16 B Y 0.02149f
C17 Y VPB 0.00883f
C18 VGND Y 0.11834f
C19 D VPB 0.06443f
C20 VPWR Y 0.00689f
C21 A VPB 0.04241f
C22 D VGND 0.06034f
C23 VGND VNB 0.24916f
C24 Y VNB 0f
C25 VPWR VNB 0f
C26 C VNB 0.05889f
C27 B VNB 0.02367f
C28 D VNB 0f
C29 A VNB 0.05009f
C30 VPB VNB 0.59313f
C31 a_31_47.t0 VNB 0.10823f
C32 a_31_47.n0 VNB 0.06992f
C33 a_31_47.n1 VNB 0.14697f
C34 a_31_47.n2 VNB 0.09652f
C35 a_31_47.n3 VNB 0.23149f
C36 a_31_47.t1 VNB 0.09236f
C37 a_270_297.t0 VNB 0.04105f
C38 a_270_297.t1 VNB 0.04821f
C39 a_354_297.t0 VNB 0.05742f
C40 a_354_297.n0 VNB 0.13637f
C41 a_354_297.n1 VNB 0.13637f
C42 a_354_297.t1 VNB 0.05691f
C43 a_354_297.t3 VNB 0.06458f
C44 a_354_297.t2 VNB 0.06067f
C45 a_752_297.t0 VNB 0.03958f
C46 a_752_297.t1 VNB 0.04475f
C47 a_270_47.t0 VNB 0.03462f
C48 a_270_47.n0 VNB 0.26712f
C49 a_270_47.n1 VNB 0.48057f
C50 a_270_47.t3 VNB 0.04086f
C51 a_270_47.t1 VNB 0.03564f
C52 a_270_47.t2 VNB 0.0384f
C53 a_511_47.t0 VNB 0.02798f
C54 a_511_47.t1 VNB 0.0332f
C55 VPB.t0 VNB 0.08262f
C56 VPB.t1 VNB 0.05562f
C57 VPB.t2 VNB 0.05562f
C58 VPB.t3 VNB 0.05562f
C59 VPB.t4 VNB 0.05562f
C60 VPB.t5 VNB 0.05562f
C61 VPB.t6 VNB 0.05215f
C62 A.n0 VNB 0.07462f
C63 D.n0 VNB 0.06438f
C64 D.n1 VNB 0.06189f
C65 D.n2 VNB 0.06494f
C66 D.n3 VNB 0.09938f
C67 B.n0 VNB 0.0581f
C68 C.n0 VNB 0.06641f
C69 VPWR.n0 VNB 0.45058f
C70 VPWR.t0 VNB 0.05163f
C71 VPWR.t2 VNB 0.0569f
C72 VPWR.n1 VNB 0.05069f
C73 VPWR.t1 VNB 0.0674f
C74 Y.t0 VNB 0.05893f
C75 Y.n0 VNB 0.04422f
C76 Y.n1 VNB 0.05716f
C77 Y.t3 VNB 0.04684f
C78 Y.t4 VNB 0.04914f
C79 Y.n2 VNB 0.13037f
C80 Y.t1 VNB 0.05085f
C81 Y.t2 VNB 0.04368f
C82 Y.n3 VNB 0.03964f
C83 VGND.n0 VNB 0.24658f
C84 VGND.t3 VNB 0.03094f
C85 VGND.t0 VNB 0.03636f
C86 VGND.n1 VNB 0.02784f
C87 VGND.n2 VNB 0.03154f
C88 VGND.t2 VNB 0.03222f
C89 VGND.t1 VNB 0.03615f
.ends
