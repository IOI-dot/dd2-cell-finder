* NGSPICE file created from dd2_g4__n4_e888_1.ext - technology: sky130A

.subckt dd2_g4__n4_e888_1 A B C D VGND VNB VPB VPWR Y
X0 VPWR.t3 D.t1 a_111_297.t1 VPB.t2 sky130_fd_pr__pfet_01v8_hvt ad=0.2475 pd=1.495 as=0.2475 ps=1.495 w=1 l=0.15 sa=3.26 sb=0.905
X1 Y.t1 a_29_297.t6 VPWR.t2 VPB.t0 sky130_fd_pr__pfet_01v8_hvt ad=0.26 pd=2.52 as=0.2475 ps=1.495 w=1 l=0.15 sa=3.905 sb=0.26
X2 a_111_297.t3 B.t3 a_29_297.t3 VPB.t5 sky130_fd_pr__pfet_01v8_hvt ad=0.2475 pd=1.495 as=0.26 ps=2.52 w=1 l=0.15 sa=0.26 sb=3.905
X3 a_582_47.t0 C.t0 a_240_47.t0 VNB.t1 sky130_fd_pr__nfet_01v8 ad=0.16087 pd=1.145 as=0.16087 ps=1.145 w=0.65 l=0.15 sa=2.615 sb=1.55
X4 a_111_297.t0 C.t1 VPWR.t0 VPB.t1 sky130_fd_pr__pfet_01v8_hvt ad=0.2475 pd=1.495 as=0.2475 ps=1.495 w=1 l=0.15 sa=2.615 sb=1.55
X5 a_111_47.t1 B.t1 VGND.t1 VNB.t5 sky130_fd_pr__nfet_01v8 ad=0.16087 pd=1.145 as=0.169 ps=1.82 w=0.65 l=0.15 sa=0.26 sb=3.905
X6 a_240_47.t2 A.t1 a_111_47.t0 VNB.t3 sky130_fd_pr__nfet_01v8 ad=0.08775 pd=0.92 as=0.16087 ps=1.145 w=0.65 l=0.15 sa=0.905 sb=3.26
X7 a_324_297.t0 A.t2 a_29_297.t2 VPB.t4 sky130_fd_pr__pfet_01v8_hvt ad=0.2475 pd=1.495 as=0.135 ps=1.27 w=1 l=0.15 sa=1.325 sb=2.84
X8 VPWR.t1 B.t2 a_324_297.t1 VPB.t6 sky130_fd_pr__pfet_01v8_hvt ad=0.2475 pd=1.495 as=0.2475 ps=1.495 w=1 l=0.15 sa=1.97 sb=2.195
X9 VGND.t0 D.t0 a_582_47.t1 VNB.t2 sky130_fd_pr__nfet_01v8 ad=0.16087 pd=1.145 as=0.16087 ps=1.145 w=0.65 l=0.15 sa=3.26 sb=0.905
X10 a_29_297.t1 A.t0 a_240_47.t1 VNB.t4 sky130_fd_pr__nfet_01v8 ad=0.16087 pd=1.145 as=0.08775 ps=0.92 w=0.65 l=0.15 sa=1.325 sb=2.84
X11 Y.t0 a_29_297.t5 VGND.t2 VNB.t0 sky130_fd_pr__nfet_01v8 ad=0.169 pd=1.82 as=0.16087 ps=1.145 w=0.65 l=0.15 sa=3.905 sb=0.26
X12 a_29_297.t0 A.t3 a_111_297.t2 VPB.t3 sky130_fd_pr__pfet_01v8_hvt ad=0.135 pd=1.27 as=0.2475 ps=1.495 w=1 l=0.15 sa=0.905 sb=3.26
X13 a_240_47.t3 B.t0 a_29_297.t4 VNB.t6 sky130_fd_pr__nfet_01v8 ad=0.16087 pd=1.145 as=0.16087 ps=1.145 w=0.65 l=0.15 sa=1.97 sb=2.195
R0 VGND VGND.n0 0.0581017
R1 VGND.n0 VGND.n1 218.781
R2 VGND.n0 VGND.t1 299.634
R3 VGND.n1 VGND.t0 46.1543
R4 VGND.n1 VGND.t2 45.2313
R5 Y Y.n0 61.405
R6 Y Y.t1 232.07
R7 Y Y.n0 1.64144
R8 Y.n0 Y.t0 133.386
R9 VPWR VPWR.n0 0.695045
R10 VPWR.n0 VPWR.n2 331.909
R11 VPWR.n2 VPWR.t3 49.2505
R12 VPWR.n2 VPWR.t2 48.2655
R13 VPWR.n0 VPWR.n1 614.314
R14 VPWR.n1 VPWR.t1 49.2505
R15 VPWR.n1 VPWR.t0 48.2655
R16 D D.n0 158.4
R17 D.n0 D.t0 158.064
R18 D.n0 D.t1 230.363
R19 C C.n0 158.4
R20 C.n0 C.t0 158.064
R21 C.n0 C.t1 230.363
R22 A A.n1 191.264
R23 A.n1 A.n0 61.346
R24 A.n1 A.t3 212.081
R25 A.n1 A.t1 139.78
R26 A.n0 A.t2 212.081
R27 A.n0 A.t0 139.78
R28 B.n1 B.n0 152
R29 B B.n1 6.4005
R30 B B.n1 147.953
R31 B B.n2 158.4
R32 B.n2 B.t0 158.064
R33 B.n2 B.t2 230.363
R34 B.n0 B.t1 158.064
R35 B.n0 B.t3 230.363
R36 VPB VPB.t5 198.287
R37 VPB.t5 VPB.t3 381.776
R38 VPB.t3 VPB.t4 248.599
R39 VPB.t4 VPB.t6 381.776
R40 VPB.t6 VPB.t1 381.776
R41 VPB.t1 VPB.t2 381.776
R42 VPB.t2 VPB.t0 381.776
R43 VNB VNB.t5 954.045
R44 VNB.t5 VNB.t3 1836.89
R45 VNB.t3 VNB.t4 1196.12
R46 VNB.t4 VNB.t6 1836.89
R47 VNB.t6 VNB.t1 1836.89
R48 VNB.t1 VNB.t2 1836.89
R49 VNB.t2 VNB.t0 1836.89
R50 a_582_47.t0 a_582_47.t1 91.3851
R51 a_240_47.n0 a_240_47.t3 46.1543
R52 a_240_47.t0 a_240_47.n0 45.2313
R53 a_240_47.n0 a_240_47.n1 458.848
R54 a_240_47.n1 a_240_47.t2 24.9236
R55 a_240_47.n1 a_240_47.t1 24.9236
R56 a_111_47.t0 a_111_47.t1 91.3851
R57 a_324_297.t0 a_324_297.t1 97.5155
R58 a_111_297.t0 a_111_297.n0 48.2655
R59 a_111_297.n0 a_111_297.t1 49.2505
R60 a_111_297.n0 a_111_297.n1 771.465
R61 a_111_297.n1 a_111_297.t3 49.2505
R62 a_111_297.n1 a_111_297.t2 48.2655
R63 a_29_297.n0 a_29_297.n1 292.5
R64 a_29_297.t0 a_29_297.n0 26.5955
R65 a_29_297.n0 a_29_297.t2 26.5955
R66 a_29_297.n1 a_29_297.n3 209.09
R67 a_29_297.n3 a_29_297.n2 152
R68 a_29_297.n3 a_29_297.n4 346.562
R69 a_29_297.n4 a_29_297.t1 45.2313
R70 a_29_297.n4 a_29_297.t4 46.1543
R71 a_29_297.n2 a_29_297.t5 158.064
R72 a_29_297.n2 a_29_297.t6 230.363
R73 a_29_297.n1 a_29_297.t3 304.113
C0 VPWR D 0.0208f
C1 VGND C 0.01466f
C2 D B 0
C3 C D 0.02721f
C4 Y VPB 0.01154f
C5 Y A 0
C6 VPWR VPB 0.11372f
C7 B VPB 0.08258f
C8 VPWR A 0.01869f
C9 C VPB 0.03953f
C10 A B 0.10866f
C11 VGND D 0.01748f
C12 VGND VPB 0.00864f
C13 VGND A 0.02367f
C14 D VPB 0.03953f
C15 Y VPWR 0.05453f
C16 Y B 0
C17 Y C 0
C18 VPWR B 0.02516f
C19 C VPWR 0.01702f
C20 C B 0.02773f
C21 A VPB 0.07104f
C22 Y VGND 0.0396f
C23 Y D 0.00118f
C24 VGND VPWR 0.04988f
C25 VGND B 0.06473f
C26 VGND VNB 0.10714f
C27 Y VNB 0.04841f
C28 VPWR VNB 0.01145f
C29 D VNB 0.01672f
C30 C VNB 0.01867f
C31 A VNB 0.02218f
C32 B VNB 0.0818f
C33 VPB VNB 0.60776f
C34 a_29_297.t0 VNB 0.04203f
C35 a_29_297.n0 VNB 0.04055f
C36 a_29_297.t3 VNB 0.12825f
C37 a_29_297.n1 VNB 0.21306f
C38 a_29_297.n2 VNB 0.06307f
C39 a_29_297.n3 VNB 0.18211f
C40 a_29_297.t1 VNB 0.03911f
C41 a_29_297.t4 VNB 0.0428f
C42 a_29_297.n4 VNB 0.08006f
C43 a_29_297.t2 VNB 0.04203f
C44 a_111_297.t0 VNB 0.05965f
C45 a_111_297.n0 VNB 0.16621f
C46 a_111_297.n1 VNB 0.16648f
C47 a_111_297.t3 VNB 0.05865f
C48 a_111_297.t2 VNB 0.05419f
C49 a_111_297.t1 VNB 0.06124f
C50 a_324_297.t0 VNB 0.04617f
C51 a_324_297.t1 VNB 0.04997f
C52 a_111_47.t0 VNB 0.03061f
C53 a_111_47.t1 VNB 0.03381f
C54 a_240_47.t0 VNB 0.04075f
C55 a_240_47.n0 VNB 0.07646f
C56 a_240_47.t2 VNB 0.0269f
C57 a_240_47.t1 VNB 0.0269f
C58 a_240_47.n1 VNB 0.05713f
C59 a_240_47.t3 VNB 0.03998f
C60 a_582_47.t0 VNB 0.03507f
C61 a_582_47.t1 VNB 0.03574f
C62 VPB.t0 VNB 0.0873f
C63 VPB.t1 VNB 0.05702f
C64 VPB.t2 VNB 0.05702f
C65 VPB.t3 VNB 0.04707f
C66 VPB.t4 VNB 0.04707f
C67 VPB.t5 VNB 0.04331f
C68 VPB.t6 VNB 0.05702f
C69 B.n0 VNB 0.07174f
C70 B.n1 VNB 0.07087f
C71 B.n2 VNB 0.07222f
C72 A.n0 VNB 0.05346f
C73 A.n1 VNB 0.07809f
C74 C.n0 VNB 0.07691f
C75 D.n0 VNB 0.07953f
C76 VPWR.n0 VNB 0.32f
C77 VPWR.t1 VNB 0.04454f
C78 VPWR.t0 VNB 0.04582f
C79 VPWR.n1 VNB 0.03803f
C80 VPWR.n2 VNB 0.04011f
C81 VPWR.t3 VNB 0.04713f
C82 VPWR.t2 VNB 0.04106f
C83 Y.n0 VNB 0.01968f
C84 Y.t0 VNB 0.03895f
C85 Y.t1 VNB 0.0646f
C86 VGND.n0 VNB 0.35519f
C87 VGND.t0 VNB 0.03024f
C88 VGND.t2 VNB 0.02594f
C89 VGND.n1 VNB 0.02204f
C90 VGND.t1 VNB 0.03808f
.ends
