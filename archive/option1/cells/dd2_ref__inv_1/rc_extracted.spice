* NGSPICE file created from dd2_ref__inv_1.ext - technology: sky130A

.subckt dd2_ref__inv_1 A VGND VNB VPB VPWR Y
X0 Y A VPWR VPB sky130_fd_pr__pfet_01v8_hvt ad=0.26 pd=2.52 as=0.26 ps=2.52 w=1 l=0.15
X1 Y A VGND VNB sky130_fd_pr__nfet_01v8 ad=0.169 pd=1.82 as=0.169 ps=1.82 w=0.65 l=0.15
C0 VGND A 0.03465f
C1 Y VPWR 0.0738f
C2 VPB Y 0.01774f
C3 VPWR A 0.0345f
C4 VPB A 0.044f
C5 VPWR VGND 0.0185f
C6 VPB VGND 0.0133f
C7 VPB VPWR 0.06749f
C8 Y A 0.03493f
C9 Y VGND 0.05944f
C10 VGND VNB 0.24423f
C11 Y VNB 0.16223f
C12 VPWR VNB 0.26946f
C13 VPB VNB 0.33898f
.ends
