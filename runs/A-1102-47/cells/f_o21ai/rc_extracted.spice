* NGSPICE file created from f_o21ai.ext - technology: sky130A

.subckt f_o21ai A B C VGND VNB VPB VPWR Y
X0 a_145_297# B VPWR VPB sky130_fd_pr__pfet_01v8_hvt ad=0.175 pd=1.35 as=0.26 ps=2.52 w=1 l=0.15 sa=0.26 sb=1.26
X1 a_63_47# A VGND VNB sky130_fd_pr__nfet_01v8 ad=0.11375 pd=1 as=0.11375 ps=1 w=0.65 l=0.15 sa=0.76 sb=0.76
X2 VPWR C Y.t1 VPB sky130_fd_pr__pfet_01v8_hvt ad=0.26 pd=2.52 as=0.175 ps=1.35 w=1 l=0.15 sa=1.26 sb=0.26
X3 VGND B a_63_47# VNB sky130_fd_pr__nfet_01v8 ad=0.11375 pd=1 as=0.169 ps=1.82 w=0.65 l=0.15 sa=0.26 sb=1.26
X4 Y.t0 A a_145_297# VPB sky130_fd_pr__pfet_01v8_hvt ad=0.175 pd=1.35 as=0.175 ps=1.35 w=1 l=0.15 sa=0.76 sb=0.76
X5 Y.t2 C a_63_47# VNB sky130_fd_pr__nfet_01v8 ad=0.169 pd=1.82 as=0.11375 ps=1 w=0.65 l=0.15 sa=1.26 sb=0.26
R0 Y.n1 Y 588.298
R1 Y.n2 Y.n1 294.228
R2 Y.n0 Y.t2 249.615
R3 Y.n0 Y.n2 135.786
R4 Y.n1 Y.t0 34.4755
R5 Y.n1 Y.t1 34.4755
R6 Y.n2 Y 11.4261
R7 Y.n0 Y 6.8005
R8 Y Y.n0 3.4005
C0 VPWR VGND 0.02685f
C1 a_145_297# VPWR 0.02253f
C2 C Y 0.04758f
C3 C VPWR 0.01713f
C4 VPB Y 0.01825f
C5 A B 0.03085f
C6 B a_63_47# 0.02731f
C7 VPB VPWR 0.09691f
C8 A a_63_47# 0.02675f
C9 B VGND 0.01554f
C10 A VGND 0.01664f
C11 B a_145_297# 0
C12 a_63_47# VGND 0.10095f
C13 A a_145_297# 0.00288f
C14 a_145_297# a_63_47# 0.00225f
C15 a_145_297# VGND 0.00276f
C16 A C 0.03085f
C17 C a_63_47# 0.01154f
C18 B VPB 0.03487f
C19 C VGND 0.01711f
C20 A VPB 0.03106f
C21 VPB a_63_47# 0.00222f
C22 VPB VGND 0.01146f
C23 VPWR Y 0.08793f
C24 C VPB 0.03321f
C25 B Y 0.00446f
C26 A Y 0.01048f
C27 a_63_47# Y 0.02361f
C28 B VPWR 0.03224f
C29 A VPWR 0.02192f
C30 VGND Y 0.02906f
C31 VPWR a_63_47# 0.00614f
C32 a_145_297# Y 0.00854f
C33 VGND VNB 0.33302f
C34 Y VNB 0.11002f
C35 VPWR VNB 0.37394f
C36 VPB VNB 0.51617f
C37 a_63_47# VNB 0.06057f
C38 a_145_297# VNB 0.0447f
C39 Y.n0 VNB 0.04805f
C40 Y.t1 VNB 0.05854f
C41 Y.t0 VNB 0.017f
C42 Y.n1 VNB 0.03427f
C43 Y.n2 VNB 0.06481f
C44 Y.t2 VNB 0.02949f
.ends
