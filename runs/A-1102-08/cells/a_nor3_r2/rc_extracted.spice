* NGSPICE file created from a_nor3_r2.ext - technology: sky130A

.subckt a_nor3_r2 A B C VGND VNB VPB VPWR Y
X0 VGND A Y.t1 VNB sky130_fd_pr__nfet_01v8 ad=0.08775 pd=0.92 as=0.25675 ps=1.44 w=0.65 l=0.15 sa=1.2 sb=0.68
X1 a_109_297# B a_297_297# VPB sky130_fd_pr__pfet_01v8_hvt ad=0.26 pd=2.52 as=0.135 ps=1.27 w=1 l=0.15 sa=0.68 sb=0.26
X2 Y.t2 B VGND VNB sky130_fd_pr__nfet_01v8 ad=0.169 pd=1.82 as=0.08775 ps=0.92 w=0.65 l=0.15 sa=1.62 sb=0.26
X3 a_297_297# A Y.t0 VPB sky130_fd_pr__pfet_01v8_hvt ad=0.135 pd=1.27 as=0.26 ps=2.52 w=1 l=0.15 sa=0.26 sb=0.68
X4 a_109_297# C VPWR VPB sky130_fd_pr__pfet_01v8_hvt ad=0.26 pd=2.52 as=0.26 ps=2.52 w=1 l=0.15 sa=0.26 sb=0.26
X5 Y.t3 C VGND VNB sky130_fd_pr__nfet_01v8 ad=0.25675 pd=1.44 as=0.169 ps=1.82 w=0.65 l=0.15 sa=0.26 sb=1.62
R0 Y.n2 Y.t0 386.401
R1 Y.n4 Y.t2 271.647
R2 Y.t2 Y.n3 268.077
R3 Y.n0 Y 197.554
R4 Y.n1 Y.n0 185
R5 Y.n0 Y.t3 72.9236
R6 Y.n0 Y.t1 72.9236
R7 Y.n3 Y.n2 62.4946
R8 Y Y.n4 6.4005
R9 Y Y.n3 6.4005
R10 Y.n1 Y 4.18512
R11 Y.n2 Y.n1 2.95435
R12 Y.n4 Y 2.25932
C0 A C 0.00943f
C1 VGND Y 0.13179f
C2 a_297_297# Y 0.00686f
C3 VGND VPB 0.00921f
C4 Y C 0.01738f
C5 VPWR VGND 0.02655f
C6 VPWR a_297_297# 0.00423f
C7 C VPB 0.03779f
C8 A Y 0.05191f
C9 VPWR C 0.02986f
C10 A VPB 0.03239f
C11 a_109_297# VGND 0.00634f
C12 a_109_297# a_297_297# 0.01451f
C13 VPWR A 0.00949f
C14 a_109_297# C 0.00768f
C15 Y VPB 0.01728f
C16 VPWR Y 0.02133f
C17 a_109_297# A 0.01437f
C18 VGND B 0.01517f
C19 a_297_297# B 0
C20 VPWR VPB 0.06962f
C21 a_109_297# Y 0.05028f
C22 A B 0.03192f
C23 a_109_297# VPB 0.02115f
C24 a_109_297# VPWR 0.13826f
C25 B Y 0.03094f
C26 VGND a_297_297# 0.00185f
C27 B VPB 0.03083f
C28 VPWR B 0.00875f
C29 VGND C 0.03081f
C30 VGND A 0.01711f
C31 A a_297_297# 0
C32 a_109_297# B 0.02486f
C33 VGND VNB 0.36344f
C34 Y VNB 0.08778f
C35 VPWR VNB 0.33165f
C36 VPB VNB 0.51617f
C37 a_297_297# VNB 0.04532f
C38 a_109_297# VNB 0.12939f
C39 Y.t0 VNB 0.05424f
C40 Y.t1 VNB 0.05678f
C41 Y.t3 VNB 0.02399f
C42 Y.n0 VNB 0.04878f
C43 Y.n1 VNB 0.00352f
C44 Y.n2 VNB 0.07274f
C45 Y.n3 VNB 0.02058f
C46 Y.t2 VNB 0.02507f
C47 Y.n4 VNB 0.03198f
.ends
