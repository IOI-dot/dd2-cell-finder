* NGSPICE file created from a_nor3_r1.ext - technology: sky130A

.subckt a_nor3_r1 A B C VGND VNB VPB VPWR Y
X0 a_145_297# A Y VPB sky130_fd_pr__pfet_01v8_hvt ad=0.175 pd=1.35 as=0.26 ps=2.52 w=1 l=0.15 sa=0.26 sb=1.26
X1 VGND B Y VNB sky130_fd_pr__nfet_01v8 ad=0.11375 pd=1 as=0.11375 ps=1 w=0.65 l=0.15 sa=0.76 sb=0.76
X2 VPWR C a_245_297# VPB sky130_fd_pr__pfet_01v8_hvt ad=0.26 pd=2.52 as=0.175 ps=1.35 w=1 l=0.15 sa=1.26 sb=0.26
X3 Y A VGND VNB sky130_fd_pr__nfet_01v8 ad=0.11375 pd=1 as=0.169 ps=1.82 w=0.65 l=0.15 sa=0.26 sb=1.26
X4 a_245_297# B a_145_297# VPB sky130_fd_pr__pfet_01v8_hvt ad=0.175 pd=1.35 as=0.175 ps=1.35 w=1 l=0.15 sa=0.76 sb=0.76
X5 Y C VGND VNB sky130_fd_pr__nfet_01v8 ad=0.169 pd=1.82 as=0.11375 ps=1 w=0.65 l=0.15 sa=1.26 sb=0.26
C0 a_245_297# Y 0.00789f
C1 VPWR A 0.01574f
C2 VGND A 0.01771f
C3 VPWR C 0.02795f
C4 VGND C 0.01568f
C5 B Y 0.03305f
C6 Y A 0.0558f
C7 a_245_297# B 0
C8 VPWR VPB 0.09183f
C9 Y C 0.02895f
C10 VGND VPB 0.00924f
C11 a_245_297# C 0.00288f
C12 B A 0.03085f
C13 Y VPB 0.02518f
C14 B C 0.03085f
C15 VPWR a_145_297# 0.01863f
C16 VGND a_145_297# 0.00276f
C17 B VPB 0.03109f
C18 VPB A 0.03373f
C19 VGND VPWR 0.02549f
C20 Y a_145_297# 0.01123f
C21 VPB C 0.03536f
C22 VPWR Y 0.06439f
C23 VGND Y 0.14152f
C24 a_245_297# VPWR 0.02219f
C25 a_245_297# VGND 0.00276f
C26 B a_145_297# 0.00288f
C27 A a_145_297# 0
C28 B VPWR 0.02136f
C29 B VGND 0.01725f
C30 VGND VNB 0.34658f
C31 VPWR VNB 0.32326f
C32 Y VNB 0.19324f
C33 VPB VNB 0.51617f
C34 a_245_297# VNB 0.04467f
C35 a_145_297# VNB 0.04151f
.ends
