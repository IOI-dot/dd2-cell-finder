* NGSPICE file created from a_nor3_r3.ext - technology: sky130A

.subckt a_nor3_r3 A B C VGND VNB VPB VPWR Y
X0 VGND C Y VNB sky130_fd_pr__nfet_01v8 ad=0.08775 pd=0.92 as=0.25675 ps=1.44 w=0.65 l=0.15 sa=1.2 sb=0.68
X1 a_109_297# B a_297_297# VPB sky130_fd_pr__pfet_01v8_hvt ad=0.26 pd=2.52 as=0.135 ps=1.27 w=1 l=0.15 sa=0.68 sb=0.26
X2 Y B VGND VNB sky130_fd_pr__nfet_01v8 ad=0.169 pd=1.82 as=0.08775 ps=0.92 w=0.65 l=0.15 sa=1.62 sb=0.26
X3 a_297_297# C VPWR VPB sky130_fd_pr__pfet_01v8_hvt ad=0.135 pd=1.27 as=0.26 ps=2.52 w=1 l=0.15 sa=0.26 sb=0.68
X4 a_109_297# A Y VPB sky130_fd_pr__pfet_01v8_hvt ad=0.26 pd=2.52 as=0.26 ps=2.52 w=1 l=0.15 sa=0.26 sb=0.26
X5 Y A VGND VNB sky130_fd_pr__nfet_01v8 ad=0.25675 pd=1.44 as=0.169 ps=1.82 w=0.65 l=0.15 sa=0.26 sb=1.62
C0 a_297_297# B 0
C1 C A 0.00943f
C2 Y VPB 0.02152f
C3 C B 0.03192f
C4 VPWR a_109_297# 0.10094f
C5 VGND a_109_297# 0.00414f
C6 C VPB 0.03242f
C7 VPB A 0.03539f
C8 VGND VPWR 0.02447f
C9 Y a_109_297# 0.05539f
C10 VPB B 0.03042f
C11 a_297_297# a_109_297# 0.0151f
C12 VPWR Y 0.03982f
C13 VGND Y 0.13997f
C14 a_297_297# VPWR 0.00934f
C15 a_297_297# VGND 0.00176f
C16 C a_109_297# 0.02135f
C17 A a_109_297# 0.00473f
C18 C VPWR 0.01779f
C19 B a_109_297# 0.02682f
C20 C VGND 0.01715f
C21 a_297_297# Y 0.00279f
C22 VPWR A 0.01295f
C23 VGND A 0.03043f
C24 VPWR B 0.0124f
C25 VGND B 0.01504f
C26 VPB a_109_297# 0.02285f
C27 C Y 0.03737f
C28 Y A 0.04773f
C29 a_297_297# C 0
C30 VPWR VPB 0.06613f
C31 Y B 0.02898f
C32 VGND VPB 0.00831f
C33 VGND VNB 0.36284f
C34 VPWR VNB 0.24719f
C35 Y VNB 0.18334f
C36 VPB VNB 0.51617f
C37 a_297_297# VNB 0.04532f
C38 a_109_297# VNB 0.13054f
.ends
