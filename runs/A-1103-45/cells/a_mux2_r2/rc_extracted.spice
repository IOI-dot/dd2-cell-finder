* NGSPICE file created from a_mux2_r2.ext - technology: sky130A

.subckt a_mux2_r2 A B C VGND VNB VPB VPWR Y
X0 a_253_297.t0 A.t1 a_431_47.t0 VPB.t0 sky130_fd_pr__pfet_01v8_hvt ad=0.26 pd=2.52 as=0.135 ps=1.27 w=1 l=0.15 sa=1.66 sb=0.26
X1 Y.t1 a_431_47.t4 VGND.t3 VNB.t1 sky130_fd_pr__nfet_01v8 ad=0.169 pd=1.82 as=0.25675 ps=1.44 w=0.65 l=0.15 sa=3.54 sb=0.26
X2 Y.t0 a_431_47.t5 VPWR.t3 VPB.t1 sky130_fd_pr__pfet_01v8_hvt ad=0.26 pd=2.52 as=0.26 ps=2.52 w=1 l=0.15 sa=0.26 sb=0.26
X3 VGND.t2 C.t1 a_65_47.t1 VNB.t4 sky130_fd_pr__nfet_01v8 ad=0.25675 pd=1.44 as=0.169 ps=1.82 w=0.65 l=0.15 sa=0.26 sb=3.54
X4 VPWR.t1 C.t3 a_65_47.t0 VPB.t4 sky130_fd_pr__pfet_01v8_hvt ad=0.26 pd=2.52 as=0.26 ps=2.52 w=1 l=0.15 sa=0.26 sb=0.26
X5 a_431_47.t1 a_65_47.t3 a_253_297.t1 VPB.t2 sky130_fd_pr__pfet_01v8_hvt ad=0.135 pd=1.27 as=0.175 ps=1.35 w=1 l=0.15 sa=1.24 sb=0.68
X6 a_531_47.t1 a_65_47.t2 a_431_47.t3 VNB.t3 sky130_fd_pr__nfet_01v8 ad=0.08775 pd=0.92 as=0.11375 ps=1 w=0.65 l=0.15 sa=2.18 sb=1.62
X7 a_431_47.t2 B.t0 a_335_47.t0 VNB.t2 sky130_fd_pr__nfet_01v8 ad=0.11375 pd=1 as=0.10725 ps=0.98 w=0.65 l=0.15 sa=1.68 sb=2.12
X8 a_253_297.t2 B.t1 VPWR.t2 VPB.t3 sky130_fd_pr__pfet_01v8_hvt ad=0.175 pd=1.35 as=0.165 ps=1.33 w=1 l=0.15 sa=0.74 sb=1.18
X9 VGND.t0 A.t0 a_531_47.t0 VNB.t0 sky130_fd_pr__nfet_01v8 ad=0.25675 pd=1.44 as=0.08775 ps=0.92 w=0.65 l=0.15 sa=2.6 sb=1.2
X10 VPWR.t0 C.t2 a_253_297.t3 VPB.t5 sky130_fd_pr__pfet_01v8_hvt ad=0.165 pd=1.33 as=0.26 ps=2.52 w=1 l=0.15 sa=0.26 sb=1.66
X11 a_335_47.t1 C.t0 VGND.t1 VNB.t5 sky130_fd_pr__nfet_01v8 ad=0.10725 pd=0.98 as=0.25675 ps=1.44 w=0.65 l=0.15 sa=1.2 sb=2.6
R0 VGND VGND.n0 0.260336
R1 VGND.n0 VGND.n1 215.242
R2 VGND.n0 VGND.n2 128.118
R3 VGND.n2 VGND.t2 72.9236
R4 VGND.n2 VGND.t1 72.9236
R5 VGND.n1 VGND.t0 72.9236
R6 VGND.n1 VGND.t3 72.9236
R7 Y Y.n0 6.4005
R8 Y.n1 Y.t0 227.356
R9 Y Y.n1 6.4005
R10 Y.n1 Y.n0 79.0593
R11 Y.n0 Y.t1 134.204
R12 VPWR.n2 VPWR.n1 9.3005
R13 VPWR.n4 VPWR.n3 9.3005
R14 VPWR VPWR.n0 0.121778
R15 VPWR.n0 VPWR.n2 0.141672
R16 VPWR.n2 VPWR.n4 0.120292
R17 VPWR.n4 VPWR.n5 0.169397
R18 VPWR.n5 VPWR.t3 360.106
R19 VPWR.n0 VPWR.n6 21.212
R20 VPWR.n6 VPWR.n1 21.0829
R21 VPWR.n1 VPWR.n3 34.6358
R22 VPWR.n3 VPWR.n8 17.3181
R23 VPWR.n5 VPWR.n8 24.8966
R24 VPWR.n8 VPWR.n7 607.212
R25 VPWR.n7 VPWR.t0 32.5055
R26 VPWR.n7 VPWR.t2 32.5055
R27 VPWR.n6 VPWR.t1 347.57
R28 A A.n0 158.4
R29 A.n0 A.t0 169.237
R30 A.n0 A.t1 241.536
R31 B B.n0 158.4
R32 B.n0 B.t0 169.237
R33 B.n0 B.t1 241.536
R34 C C.n1 167.165
R35 C.n1 C.n0 137.298
R36 C.n1 C.t3 212.081
R37 C.n1 C.t1 139.78
R38 C.n0 C.t2 212.081
R39 C.n0 C.t0 139.78
R40 VPB VPB.t4 304.829
R41 VPB.t4 VPB.t5 556.386
R42 VPB.t5 VPB.t3 284.113
R43 VPB.t3 VPB.t2 295.95
R44 VPB.t2 VPB.t0 248.599
R45 VPB.t0 VPB.t1 556.386
R46 VNB VNB.t4 1466.67
R47 VNB.t4 VNB.t5 2677.02
R48 VNB.t5 VNB.t2 1366.99
R49 VNB.t2 VNB.t3 1423.95
R50 VNB.t3 VNB.t0 1196.12
R51 VNB.t0 VNB.t1 2677.02
R52 a_531_47.t0 a_531_47.t1 49.8467
R53 a_335_47.t0 a_335_47.t1 60.9236
R54 a_253_297.t0 a_253_297.n0 383.769
R55 a_253_297.n0 a_253_297.n1 292.5
R56 a_253_297.n0 a_253_297.t3 389.599
R57 a_253_297.n1 a_253_297.t2 34.4755
R58 a_253_297.n1 a_253_297.t1 34.4755
R59 a_431_47.n0 a_431_47.t1 26.5955
R60 a_431_47.t0 a_431_47.n0 26.5955
R61 a_431_47.n0 a_431_47.n2 655.777
R62 a_431_47.n2 a_431_47.n3 182.119
R63 a_431_47.n3 a_431_47.t4 169.237
R64 a_431_47.n3 a_431_47.t5 241.536
R65 a_431_47.n2 a_431_47.n1 191.476
R66 a_431_47.n1 a_431_47.t2 32.3082
R67 a_431_47.n1 a_431_47.t3 32.3082
R68 a_65_47.t0 a_65_47.n0 218.792
R69 a_65_47.n0 a_65_47.n1 334.026
R70 a_65_47.n1 a_65_47.t2 169.237
R71 a_65_47.n1 a_65_47.t3 241.536
R72 a_65_47.n0 a_65_47.t1 242.915
C0 A VPB 0.03134f
C1 Y VPB 0.01872f
C2 C VPB 0.09844f
C3 VPWR VPB 0.14595f
C4 Y B 0
C5 C B 0.03175f
C6 VPWR B 0.01592f
C7 Y A 0
C8 VPWR A 0.01026f
C9 VGND VPB 0.01659f
C10 Y C 0
C11 VPWR Y 0.05942f
C12 VPWR C 0.03901f
C13 VGND B 0.01982f
C14 VGND A 0.01532f
C15 VGND Y 0.04239f
C16 VGND C 0.05205f
C17 VGND VPWR 0.05286f
C18 B VPB 0.02789f
C19 VGND VNB 0.15782f
C20 Y VNB 0f
C21 VPWR VNB 0f
C22 A VNB 0.02846f
C23 B VNB 0.0235f
C24 C VNB 0.05353f
C25 VPB VNB 0.59607f
C26 a_65_47.t0 VNB 0.08923f
C27 a_65_47.n0 VNB 0.23649f
C28 a_65_47.t1 VNB 0.09927f
C29 a_65_47.n1 VNB 0.08576f
C30 a_431_47.t0 VNB 0.04662f
C31 a_431_47.n0 VNB 0.04064f
C32 a_431_47.n1 VNB 0.06908f
C33 a_431_47.t2 VNB 0.03542f
C34 a_431_47.t3 VNB 0.03136f
C35 a_431_47.n2 VNB 0.1523f
C36 a_431_47.n3 VNB 0.04465f
C37 a_431_47.t1 VNB 0.04033f
C38 a_253_297.t0 VNB 0.09574f
C39 a_253_297.n0 VNB 0.15732f
C40 a_253_297.n1 VNB 0.04119f
C41 a_253_297.t2 VNB 0.04799f
C42 a_253_297.t1 VNB 0.04238f
C43 a_253_297.t3 VNB 0.08899f
C44 a_335_47.t0 VNB 0.03205f
C45 a_335_47.t1 VNB 0.02696f
C46 a_531_47.t0 VNB 0.02953f
C47 a_531_47.t1 VNB 0.02498f
C48 VPB.t0 VNB 0.06506f
C49 VPB.t1 VNB 0.12629f
C50 VPB.t2 VNB 0.04401f
C51 VPB.t3 VNB 0.04688f
C52 VPB.t4 VNB 0.0696f
C53 VPB.t5 VNB 0.06793f
C54 C.n0 VNB 0.07667f
C55 C.n1 VNB 0.08782f
C56 B.n0 VNB 0.0555f
C57 A.n0 VNB 0.05688f
C58 VPWR.n0 VNB 0.04275f
C59 VPWR.n1 VNB 0.01004f
C60 VPWR.n2 VNB 0.04058f
C61 VPWR.n3 VNB 0.00936f
C62 VPWR.n4 VNB 0.07249f
C63 VPWR.n5 VNB 0.26348f
C64 VPWR.t1 VNB 0.06168f
C65 VPWR.n6 VNB 0.03293f
C66 VPWR.t0 VNB 0.03424f
C67 VPWR.t2 VNB 0.04063f
C68 VPWR.n7 VNB 0.02665f
C69 VPWR.n8 VNB 0.02206f
C70 VPWR.t3 VNB 0.06294f
C71 Y.t1 VNB 0.03798f
C72 Y.n0 VNB 0.0435f
C73 Y.t0 VNB 0.06224f
C74 Y.n1 VNB 0.05942f
C75 VGND.n0 VNB 0.27297f
C76 VGND.t0 VNB 0.03329f
C77 VGND.t3 VNB 0.02805f
C78 VGND.n1 VNB 0.02751f
C79 VGND.n2 VNB 0.02975f
C80 VGND.t2 VNB 0.0277f
C81 VGND.t1 VNB 0.0277f
.ends
