* NGSPICE file created from a_mux2_r1.ext - technology: sky130A

.subckt a_mux2_r1 A B C VGND VNB VPB VPWR Y
X0 a_253_297# C VPWR VPB sky130_fd_pr__pfet_01v8_hvt ad=0.26 pd=2.52 as=0.165 ps=1.33 w=1 l=0.15 sa=1.66 sb=0.26
X1 a_93_199# a_389_21# a_335_47# VNB sky130_fd_pr__nfet_01v8 ad=0.11375 pd=1 as=0.08775 ps=0.92 w=0.65 l=0.15 sa=1.62 sb=2.18
X2 a_389_21# C VGND VNB sky130_fd_pr__nfet_01v8 ad=0.169 pd=1.82 as=0.25675 ps=1.44 w=0.65 l=0.15 sa=3.54 sb=0.26
X3 VPWR B a_253_297# VPB sky130_fd_pr__pfet_01v8_hvt ad=0.165 pd=1.33 as=0.175 ps=1.35 w=1 l=0.15 sa=1.18 sb=0.74
X4 a_253_297# a_389_21# a_93_199# VPB sky130_fd_pr__pfet_01v8_hvt ad=0.175 pd=1.35 as=0.135 ps=1.27 w=1 l=0.15 sa=0.68 sb=1.24
X5 a_389_21# C VPWR VPB sky130_fd_pr__pfet_01v8_hvt ad=0.26 pd=2.52 as=0.26 ps=2.52 w=1 l=0.15 sa=0.26 sb=0.26
X6 VGND a_93_199# Y VNB sky130_fd_pr__nfet_01v8 ad=0.25675 pd=1.44 as=0.169 ps=1.82 w=0.65 l=0.15 sa=0.26 sb=3.54
X7 VPWR a_93_199# Y VPB sky130_fd_pr__pfet_01v8_hvt ad=0.26 pd=2.52 as=0.26 ps=2.52 w=1 l=0.15 sa=0.26 sb=0.26
X8 VGND C a_519_47# VNB sky130_fd_pr__nfet_01v8 ad=0.25675 pd=1.44 as=0.10725 ps=0.98 w=0.65 l=0.15 sa=2.6 sb=1.2
X9 a_93_199# A a_253_297# VPB sky130_fd_pr__pfet_01v8_hvt ad=0.135 pd=1.27 as=0.26 ps=2.52 w=1 l=0.15 sa=0.26 sb=1.66
X10 a_335_47# A VGND VNB sky130_fd_pr__nfet_01v8 ad=0.08775 pd=0.92 as=0.25675 ps=1.44 w=0.65 l=0.15 sa=1.2 sb=2.6
X11 a_519_47# B a_93_199# VNB sky130_fd_pr__nfet_01v8 ad=0.10725 pd=0.98 as=0.11375 ps=1 w=0.65 l=0.15 sa=2.12 sb=1.68
C0 A a_253_297# 0.01356f
C1 B a_253_297# 0.01305f
C2 A a_389_21# 0.03357f
C3 C VPB 0.09844f
C4 B a_389_21# 0.05222f
C5 VPB a_93_199# 0.05747f
C6 a_389_21# a_519_47# 0.0018f
C7 a_253_297# VGND 0.00538f
C8 a_389_21# VGND 0.08545f
C9 A VPWR 0.01026f
C10 B VPWR 0.01592f
C11 a_519_47# VPWR 0.00149f
C12 A Y 0
C13 B Y 0
C14 VGND VPWR 0.05223f
C15 C a_253_297# 0.01406f
C16 C a_389_21# 0.08614f
C17 a_253_297# a_93_199# 0.03814f
C18 a_335_47# VPWR 0
C19 a_389_21# a_93_199# 0.04589f
C20 Y VGND 0.04595f
C21 VPB a_253_297# 0.01342f
C22 VPB a_389_21# 0.06631f
C23 a_335_47# Y 0
C24 C VPWR 0.03901f
C25 a_93_199# VPWR 0.04429f
C26 C Y 0
C27 VPB VPWR 0.14508f
C28 a_93_199# Y 0.06065f
C29 VPB Y 0.02147f
C30 B a_519_47# 0.00229f
C31 a_253_297# a_389_21# 0.07848f
C32 A VGND 0.01532f
C33 B VGND 0.01982f
C34 a_519_47# VGND 0.01371f
C35 a_335_47# VGND 0.0077f
C36 a_253_297# VPWR 0.19815f
C37 a_389_21# VPWR 0.10013f
C38 B C 0.03175f
C39 A a_93_199# 0.06864f
C40 a_253_297# Y 0
C41 B a_93_199# 0.00686f
C42 a_389_21# Y 0
C43 A VPB 0.03141f
C44 a_93_199# a_519_47# 0.0051f
C45 C VGND 0.05205f
C46 B VPB 0.02789f
C47 a_93_199# VGND 0.11531f
C48 a_335_47# a_93_199# 0.00928f
C49 VPB VGND 0.01527f
C50 Y VPWR 0.06166f
C51 C a_93_199# 0.00323f
C52 VGND VNB 0.63222f
C53 VPWR VNB 0.556f
C54 Y VNB 0.18786f
C55 VPB VNB 0.95915f
C56 a_335_47# VNB 0.07785f
C57 a_253_297# VNB 0.16099f
C58 a_93_199# VNB 0.03279f
.ends
