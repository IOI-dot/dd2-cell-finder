* NGSPICE file created from a_o22ai_r0.ext - technology: sky130A

.subckt a_o22ai_r0 A B C D VGND VNB VPB VPWR Y
X0 a_241_297# A Y VPB sky130_fd_pr__pfet_01v8_hvt ad=0.175 pd=1.35 as=0.175 ps=1.35 w=1 l=0.15 sa=0.76 sb=1.26
X1 a_141_47# B Y VNB sky130_fd_pr__nfet_01v8 ad=0.11375 pd=1 as=0.11375 ps=1 w=0.65 l=0.15 sa=1.26 sb=0.76
X2 Y C a_59_297# VPB sky130_fd_pr__pfet_01v8_hvt ad=0.175 pd=1.35 as=0.26 ps=2.52 w=1 l=0.15 sa=0.26 sb=1.76
X3 Y A a_141_47# VNB sky130_fd_pr__nfet_01v8 ad=0.11375 pd=1 as=0.11375 ps=1 w=0.65 l=0.15 sa=0.76 sb=1.26
X4 a_59_297# D VPWR VPB sky130_fd_pr__pfet_01v8_hvt ad=0.26 pd=2.52 as=0.175 ps=1.35 w=1 l=0.15 sa=1.76 sb=0.26
X5 a_141_47# C VGND VNB sky130_fd_pr__nfet_01v8 ad=0.11375 pd=1 as=0.169 ps=1.82 w=0.65 l=0.15 sa=0.26 sb=1.76
X6 VPWR B a_241_297# VPB sky130_fd_pr__pfet_01v8_hvt ad=0.175 pd=1.35 as=0.175 ps=1.35 w=1 l=0.15 sa=1.26 sb=0.76
X7 VGND D a_141_47# VNB sky130_fd_pr__nfet_01v8 ad=0.169 pd=1.82 as=0.11375 ps=1 w=0.65 l=0.15 sa=1.76 sb=0.26
C0 VGND C 0.02986f
C1 VGND a_241_297# 0.00148f
C2 VPWR VPB 0.07781f
C3 VPB D 0.03234f
C4 VGND VPB 0.01161f
C5 Y a_59_297# 0.08603f
C6 a_241_297# B 0
C7 VPB B 0.0282f
C8 a_241_297# A 0
C9 A C 0.03085f
C10 a_141_47# a_59_297# 0
C11 A VPB 0.0282f
C12 a_141_47# Y 0.05224f
C13 C a_59_297# 0.02551f
C14 a_241_297# a_59_297# 0.01607f
C15 VPB a_59_297# 0.02092f
C16 a_241_297# Y 0.00952f
C17 Y C 0.00364f
C18 Y VPB 0.01829f
C19 a_141_47# C 0.00543f
C20 a_141_47# VPB 0
C21 VPWR D 0.0145f
C22 VGND VPWR 0.02983f
C23 VGND D 0.01657f
C24 VPWR B 0.01241f
C25 B D 0.03085f
C26 VGND B 0.00998f
C27 C VPB 0.03326f
C28 VPWR A 0.00944f
C29 VGND A 0.0109f
C30 A B 0.03085f
C31 VPWR a_59_297# 0.16713f
C32 a_59_297# D 0.01291f
C33 VGND a_59_297# 0.00699f
C34 VPWR Y 0.02036f
C35 a_59_297# B 0.01288f
C36 Y D 0.05496f
C37 VGND Y 0.03713f
C38 Y B 0.04223f
C39 A a_59_297# 0.01319f
C40 VPWR a_141_47# 0.00254f
C41 a_141_47# D 0.00212f
C42 VGND a_141_47# 0.11569f
C43 Y A 0.02578f
C44 a_141_47# B 0.0075f
C45 a_141_47# A 0.02061f
C46 VPWR a_241_297# 0.00429f
C47 VPWR C 0.0094f
C48 VGND VNB 0.39219f
C49 VPWR VNB 0.32769f
C50 Y VNB 0.16868f
C51 VPB VNB 0.60476f
C52 a_141_47# VNB 0.03538f
C53 a_241_297# VNB 0.02845f
C54 a_59_297# VNB 0.13485f
.ends
