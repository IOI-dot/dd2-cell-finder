* NGSPICE file created from a_nand2_r0.ext - technology: sky130A

.subckt a_nand2_r0 A B VGND VNB VPB VPWR Y
X0 Y.t1 B.t1 VPWR.t0 VPB.t0 sky130_fd_pr__pfet_01v8_hvt ad=0.135 pd=1.27 as=0.26 ps=2.52 w=1 l=0.15 sa=0.26 sb=0.68
X1 Y.t0 A.t0 a_111_47.t1 VNB.t1 sky130_fd_pr__nfet_01v8 ad=0.169 pd=1.82 as=0.08775 ps=0.92 w=0.65 l=0.15 sa=0.68 sb=0.26
X2 a_111_47.t0 B.t0 VGND.t0 VNB.t0 sky130_fd_pr__nfet_01v8 ad=0.08775 pd=0.92 as=0.169 ps=1.82 w=0.65 l=0.15 sa=0.26 sb=0.68
X3 VPWR.t1 A.t1 Y.t2 VPB.t1 sky130_fd_pr__pfet_01v8_hvt ad=0.26 pd=2.52 as=0.135 ps=1.27 w=1 l=0.15 sa=0.68 sb=0.26
R0 VGND VGND.t0 169.627
R1 Y Y.n1 5.00031
R2 Y.n0 Y.n2 190.346
R3 Y.n0 Y.n1 77.9904
R4 Y Y.n0 10.8014
R5 Y.n2 Y.t1 26.5955
R6 Y.n2 Y.t2 26.5955
R7 Y.n1 Y.t0 130.052
R8 VPWR VPWR.n0 0.567428
R9 VPWR.n0 VPWR.t1 266.485
R10 VPWR.n0 VPWR.t0 266.312
R11 A A.n0 158.4
R12 A.n0 A.t0 158.064
R13 A.n0 A.t1 230.363
R14 B B.n0 158.4
R15 B.n0 B.t0 158.064
R16 B.n0 B.t1 230.363
R17 VPB VPB.t0 198.287
R18 VPB.t0 VPB.t1 248.599
R19 VNB VNB.t0 954.045
R20 VNB.t0 VNB.t1 1196.12
R21 a_111_47.t0 a_111_47.t1 49.8467
C0 VGND VPB 0.0054f
C1 B VGND 0.0364f
C2 A VPWR 0.03487f
C3 Y VPB 0.00643f
C4 B Y 0.03232f
C5 A VGND 0.01068f
C6 VGND VPWR 0.01786f
C7 A Y 0.05738f
C8 B VPB 0.03893f
C9 Y VPWR 0.11065f
C10 VGND Y 0.0736f
C11 A VPB 0.03893f
C12 A B 0.02548f
C13 VPWR VPB 0.05939f
C14 B VPWR 0.03565f
C15 VGND VNB 0.32359f
C16 Y VNB 0f
C17 VPWR VNB 0.11195f
C18 A VNB 0.05722f
C19 B VNB 0.05743f
C20 VPB VNB 0.27502f
C21 a_111_47.t0 VNB 0.02409f
C22 a_111_47.t1 VNB 0.02394f
C23 VPB.t0 VNB 0.03198f
C24 VPB.t1 VNB 0.07454f
C25 B.n0 VNB 0.06806f
C26 A.n0 VNB 0.06748f
C27 VPWR.n0 VNB 0.08939f
C28 VPWR.t0 VNB 0.06329f
C29 VPWR.t1 VNB 0.06314f
C30 Y.n0 VNB 0.04666f
C31 Y.n1 VNB 0.07838f
C32 Y.t0 VNB 0.0495f
C33 Y.n2 VNB 0.03303f
C34 Y.t1 VNB 0.04065f
C35 Y.t2 VNB 0.04044f
C36 VGND.t0 VNB 0.03854f
.ends
