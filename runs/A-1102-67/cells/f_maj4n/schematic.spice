.subckt f_maj4n A B C D VGND VNB VPB VPWR Y
X0 Y C n1 VNB sky130_fd_pr__nfet_01v8 w=650000u l=150000u
X1 Y D n1 VNB sky130_fd_pr__nfet_01v8 w=650000u l=150000u
X2 n1 A n2 VNB sky130_fd_pr__nfet_01v8 w=650000u l=150000u
X3 n2 B VGND VNB sky130_fd_pr__nfet_01v8 w=650000u l=150000u
X4 n1 C n3 VNB sky130_fd_pr__nfet_01v8 w=650000u l=150000u
X5 n3 D VGND VNB sky130_fd_pr__nfet_01v8 w=650000u l=150000u
X6 Y C p1 VPB sky130_fd_pr__pfet_01v8_hvt w=1000000u l=150000u
X7 p1 D VPWR VPB sky130_fd_pr__pfet_01v8_hvt w=1000000u l=150000u
X8 Y A p2 VPB sky130_fd_pr__pfet_01v8_hvt w=1000000u l=150000u
X9 Y B p2 VPB sky130_fd_pr__pfet_01v8_hvt w=1000000u l=150000u
X10 p2 C VPWR VPB sky130_fd_pr__pfet_01v8_hvt w=1000000u l=150000u
X11 p2 D VPWR VPB sky130_fd_pr__pfet_01v8_hvt w=1000000u l=150000u
.ends
