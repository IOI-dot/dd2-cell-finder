* NGSPICE file created from f_maj4n.ext - technology: sky130A

.subckt f_maj4n A B C D VGND VNB VPB VPWR Y
X0 a_110_297# D VPWR VPB sky130_fd_pr__pfet_01v8_hvt ad=0.135 pd=1.27 as=0.26 ps=2.52 w=1 l=0.15 sa=0.26 sb=2.99
X1 a_572_47# A a_194_47# VNB sky130_fd_pr__nfet_01v8 ad=0.08775 pd=0.92 as=0.10725 ps=0.98 w=0.65 l=0.15 sa=2.57 sb=0.68
X2 a_194_47# C Y VNB sky130_fd_pr__nfet_01v8 ad=0.10725 pd=0.98 as=0.19987 ps=1.265 w=0.65 l=0.15 sa=2.09 sb=1.16
X3 VGND B a_572_47# VNB sky130_fd_pr__nfet_01v8 ad=0.169 pd=1.82 as=0.08775 ps=0.92 w=0.65 l=0.15 sa=2.99 sb=0.26
X4 a_323_297# D VPWR VPB sky130_fd_pr__pfet_01v8_hvt ad=0.3075 pd=1.615 as=0.2475 ps=1.495 w=1 l=0.15 sa=1.325 sb=1.925
X5 a_194_47# C a_110_47# VNB sky130_fd_pr__nfet_01v8 ad=0.16087 pd=1.145 as=0.08775 ps=0.92 w=0.65 l=0.15 sa=0.68 sb=2.57
X6 a_110_47# D VGND VNB sky130_fd_pr__nfet_01v8 ad=0.08775 pd=0.92 as=0.169 ps=1.82 w=0.65 l=0.15 sa=0.26 sb=2.99
X7 Y B a_110_297# VPB sky130_fd_pr__pfet_01v8_hvt ad=0.26 pd=2.52 as=0.135 ps=1.27 w=1 l=0.15 sa=2.99 sb=0.26
X8 Y C a_323_297# VPB sky130_fd_pr__pfet_01v8_hvt ad=0.165 pd=1.33 as=0.3075 ps=1.615 w=1 l=0.15 sa=2.09 sb=1.16
X9 a_110_297# A Y VPB sky130_fd_pr__pfet_01v8_hvt ad=0.135 pd=1.27 as=0.165 ps=1.33 w=1 l=0.15 sa=2.57 sb=0.68
X10 VPWR C a_110_297# VPB sky130_fd_pr__pfet_01v8_hvt ad=0.2475 pd=1.495 as=0.135 ps=1.27 w=1 l=0.15 sa=0.68 sb=2.57
X11 Y D a_194_47# VNB sky130_fd_pr__nfet_01v8 ad=0.19987 pd=1.265 as=0.16087 ps=1.145 w=0.65 l=0.15 sa=1.325 sb=1.925
C0 VPWR D 0.04508f
C1 VPB Y 0.01766f
C2 a_110_297# Y 0.05797f
C3 VPWR B 0.01221f
C4 a_194_47# Y 0.05459f
C5 a_323_297# C 0.00958f
C6 a_572_47# D 0
C7 D a_110_47# 0.00651f
C8 A C 0.03744f
C9 D a_323_297# 0
C10 VGND C 0.02717f
C11 D A 0
C12 VGND D 0.05301f
C13 B A 0.02548f
C14 a_572_47# VPWR 0
C15 VPWR a_110_47# 0
C16 VGND B 0.02553f
C17 VPWR a_323_297# 0.01603f
C18 VPB C 0.07729f
C19 VPWR A 0.00968f
C20 a_110_297# C 0.08795f
C21 VPB D 0.07176f
C22 VGND VPWR 0.04309f
C23 a_194_47# C 0.00855f
C24 a_110_297# D 0.03173f
C25 VPB B 0.03721f
C26 a_194_47# D 0.04248f
C27 a_110_297# B 0.00296f
C28 a_194_47# B 0
C29 Y C 0.03377f
C30 a_572_47# VGND 0.00762f
C31 VGND a_110_47# 0.00871f
C32 VPB VPWR 0.0991f
C33 a_110_297# VPWR 0.18702f
C34 VGND a_323_297# 0.00261f
C35 D Y 0.01757f
C36 VGND A 0.01355f
C37 a_194_47# VPWR 0.00284f
C38 Y B 0.05594f
C39 VPWR Y 0.04382f
C40 a_572_47# a_194_47# 0.0013f
C41 a_110_297# a_323_297# 0.02673f
C42 a_194_47# a_110_47# 0.00123f
C43 VPB A 0.0261f
C44 a_110_297# A 0.01107f
C45 VPB VGND 0.00882f
C46 a_194_47# A 0.00194f
C47 a_110_297# VGND 0.00516f
C48 a_572_47# Y 0.00694f
C49 a_194_47# VGND 0.10981f
C50 D C 0.16113f
C51 a_323_297# Y 0.00198f
C52 Y A 0.05436f
C53 VPB a_110_297# 0.00909f
C54 VGND Y 0.03645f
C55 a_194_47# a_110_297# 0
C56 VPWR C 0.03947f
C57 VGND VNB 0.52066f
C58 Y VNB 0.13235f
C59 VPWR VNB 0.48538f
C60 VPB VNB 0.78196f
C61 a_572_47# VNB 0.08399f
C62 a_194_47# VNB 0.10219f
C63 a_110_297# VNB 0.09893f
.ends
