* NGSPICE file created from f_a21o.ext - technology: sky130A

.subckt f_a21o A B C VGND VNB VPB VPWR Y
X0 VGND C a_243_47# VNB sky130_fd_pr__nfet_01v8 ad=0.25675 pd=1.44 as=0.11375 ps=1 w=0.65 l=0.15 sa=1.26 sb=1.2
X1 a_243_47# C a_61_297# VPB sky130_fd_pr__pfet_01v8_hvt ad=0.26 pd=2.52 as=0.175 ps=1.35 w=1 l=0.15 sa=1.26 sb=0.26
X2 a_243_47# A a_143_47# VNB sky130_fd_pr__nfet_01v8 ad=0.11375 pd=1 as=0.11375 ps=1 w=0.65 l=0.15 sa=0.76 sb=1.7
X3 a_61_297# A VPWR VPB sky130_fd_pr__pfet_01v8_hvt ad=0.175 pd=1.35 as=0.175 ps=1.35 w=1 l=0.15 sa=0.76 sb=0.76
X4 Y a_243_47# VPWR VPB sky130_fd_pr__pfet_01v8_hvt ad=0.26 pd=2.52 as=0.26 ps=2.52 w=1 l=0.15 sa=0.26 sb=0.26
X5 Y a_243_47# VGND VNB sky130_fd_pr__nfet_01v8 ad=0.169 pd=1.82 as=0.25675 ps=1.44 w=0.65 l=0.15 sa=2.2 sb=0.26
X6 a_143_47# B VGND VNB sky130_fd_pr__nfet_01v8 ad=0.11375 pd=1 as=0.169 ps=1.82 w=0.65 l=0.15 sa=0.26 sb=2.2
X7 VPWR B a_61_297# VPB sky130_fd_pr__pfet_01v8_hvt ad=0.175 pd=1.35 as=0.26 ps=2.52 w=1 l=0.15 sa=0.26 sb=1.26
C0 a_143_47# a_61_297# 0.00118f
C1 VPB VGND 0.01407f
C2 VPWR VGND 0.03774f
C3 C VGND 0.01608f
C4 VPB Y 0.01973f
C5 Y VPWR 0.04374f
C6 B a_243_47# 0.00292f
C7 Y C 0
C8 A a_243_47# 0.00714f
C9 A B 0.03085f
C10 a_143_47# VGND 0.01579f
C11 VPB a_243_47# 0.0627f
C12 VPWR a_243_47# 0.07997f
C13 a_61_297# VGND 0.00798f
C14 C a_243_47# 0.04882f
C15 B VPWR 0.01515f
C16 B VPB 0.03291f
C17 A VPB 0.02921f
C18 A VPWR 0.01766f
C19 A C 0.03085f
C20 a_143_47# a_243_47# 0.00554f
C21 a_61_297# a_243_47# 0.03261f
C22 VPB VPWR 0.10222f
C23 VPB C 0.03447f
C24 VPWR C 0.01741f
C25 a_143_47# B 0
C26 a_143_47# A 0.00229f
C27 B a_61_297# 0.02805f
C28 A a_61_297# 0.02555f
C29 Y VGND 0.04263f
C30 a_143_47# VPWR 0.00158f
C31 a_61_297# VPWR 0.11508f
C32 VPB a_61_297# 0.016f
C33 a_61_297# C 0.01365f
C34 a_243_47# VGND 0.113f
C35 Y a_243_47# 0.0679f
C36 B VGND 0.03013f
C37 A VGND 0.02137f
C38 VGND VNB 0.50467f
C39 Y VNB 0.17907f
C40 VPWR VNB 0.41374f
C41 VPB VNB 0.69336f
C42 a_143_47# VNB 0.07345f
C43 a_61_297# VNB 0.03155f
.ends
