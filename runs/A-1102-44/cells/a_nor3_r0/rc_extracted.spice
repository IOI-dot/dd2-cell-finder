* NGSPICE file created from a_nor3_r0.ext - technology: sky130A

.subckt a_nor3_r0 A B C VGND VNB VPB VPWR Y
X0 a_145_297# C VPWR VPB sky130_fd_pr__pfet_01v8_hvt ad=0.175 pd=1.35 as=0.26 ps=2.52 w=1 l=0.15 sa=0.26 sb=1.26
X1 VGND B Y VNB sky130_fd_pr__nfet_01v8 ad=0.11375 pd=1 as=0.11375 ps=1 w=0.65 l=0.15 sa=0.76 sb=0.76
X2 Y A a_245_297# VPB sky130_fd_pr__pfet_01v8_hvt ad=0.26 pd=2.52 as=0.175 ps=1.35 w=1 l=0.15 sa=1.26 sb=0.26
X3 Y C VGND VNB sky130_fd_pr__nfet_01v8 ad=0.11375 pd=1 as=0.169 ps=1.82 w=0.65 l=0.15 sa=0.26 sb=1.26
X4 a_245_297# B a_145_297# VPB sky130_fd_pr__pfet_01v8_hvt ad=0.175 pd=1.35 as=0.175 ps=1.35 w=1 l=0.15 sa=0.76 sb=0.76
X5 Y A VGND VNB sky130_fd_pr__nfet_01v8 ad=0.169 pd=1.82 as=0.11375 ps=1 w=0.65 l=0.15 sa=1.26 sb=0.26
C0 a_245_297# A 0.00288f
C1 B C 0.03085f
C2 VPWR VPB 0.09501f
C3 B A 0.03085f
C4 Y a_145_297# 0.00779f
C5 VGND a_145_297# 0.00276f
C6 B VPB 0.03109f
C7 VPB C 0.03487f
C8 VGND Y 0.12936f
C9 VPWR a_145_297# 0.02219f
C10 VPB A 0.03531f
C11 Y VPWR 0.0497f
C12 VGND VPWR 0.02832f
C13 a_245_297# Y 0.01131f
C14 a_245_297# VGND 0.00276f
C15 B a_145_297# 0.00288f
C16 C a_145_297# 0
C17 B Y 0.03325f
C18 B VGND 0.01725f
C19 a_245_297# VPWR 0.01863f
C20 Y C 0.00854f
C21 VGND C 0.03072f
C22 Y A 0.0517f
C23 VGND A 0.01548f
C24 B VPWR 0.02136f
C25 VPWR C 0.0322f
C26 a_245_297# B 0
C27 Y VPB 0.02176f
C28 VPWR A 0.01683f
C29 VGND VPB 0.0118f
C30 VGND VNB 0.36238f
C31 Y VNB 0.17298f
C32 VPWR VNB 0.32372f
C33 VPB VNB 0.51617f
C34 a_245_297# VNB 0.04148f
C35 a_145_297# VNB 0.04477f
.ends
