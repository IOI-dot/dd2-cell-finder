* NGSPICE file created from a_xor2_r1.ext - technology: sky130A

.subckt a_xor2_r1 A B VGND VNB VPB VPWR Y
X0 a_309_21# B VGND VNB sky130_fd_pr__nfet_01v8 ad=0.08775 pd=0.92 as=0.25675 ps=1.44 w=0.65 l=0.15 sa=2.12 sb=0.68
X1 a_309_21# A a_527_297# VPB sky130_fd_pr__pfet_01v8_hvt ad=0.26 pd=2.52 as=0.135 ps=1.27 w=1 l=0.15 sa=0.68 sb=0.26
X2 Y.t2 A a_155_47# VNB sky130_fd_pr__nfet_01v8 ad=0.08775 pd=0.92 as=0.11375 ps=1 w=0.65 l=0.15 sa=0.76 sb=2.04
X3 Y.t0 a_309_21# a_73_297# VPB sky130_fd_pr__pfet_01v8_hvt ad=0.26 pd=2.52 as=0.135 ps=1.27 w=1 l=0.15 sa=1.18 sb=0.26
X4 a_527_297# B VPWR VPB sky130_fd_pr__pfet_01v8_hvt ad=0.135 pd=1.27 as=0.26 ps=2.52 w=1 l=0.15 sa=0.26 sb=0.68
X5 a_73_297# A VPWR VPB sky130_fd_pr__pfet_01v8_hvt ad=0.135 pd=1.27 as=0.175 ps=1.35 w=1 l=0.15 sa=0.76 sb=0.68
X6 a_155_47# B VGND VNB sky130_fd_pr__nfet_01v8 ad=0.11375 pd=1 as=0.169 ps=1.82 w=0.65 l=0.15 sa=0.26 sb=2.54
X7 VGND a_309_21# Y.t1 VNB sky130_fd_pr__nfet_01v8 ad=0.25675 pd=1.44 as=0.08775 ps=0.92 w=0.65 l=0.15 sa=1.18 sb=1.62
X8 VPWR B a_73_297# VPB sky130_fd_pr__pfet_01v8_hvt ad=0.175 pd=1.35 as=0.26 ps=2.52 w=1 l=0.15 sa=0.26 sb=1.18
X9 VGND A a_309_21# VNB sky130_fd_pr__nfet_01v8 ad=0.169 pd=1.82 as=0.08775 ps=0.92 w=0.65 l=0.15 sa=2.54 sb=0.26
R0 Y.n0 Y.t0 325.269
R1 Y.n1 Y 242.447
R2 Y.n3 Y.n2 197.8
R3 Y.n2 Y.n1 185
R4 Y.n2 Y.t2 24.9236
R5 Y.n2 Y.t1 24.9236
R6 Y.n0 Y 6.77697
R7 Y.n3 Y 6.4005
R8 Y.n1 Y 6.4005
R9 Y Y.n0 6.4005
R10 Y Y.n3 2.25932
C0 Y a_155_47# 0.012f
C1 a_309_21# a_155_47# 0
C2 VGND Y 0.07319f
C3 a_309_21# VGND 0.12595f
C4 a_527_297# Y 0
C5 a_309_21# a_527_297# 0.0123f
C6 Y VPB 0.02527f
C7 a_309_21# VPB 0.066f
C8 VPWR VGND 0.00928f
C9 VPWR a_527_297# 0.01462f
C10 B Y 0.11648f
C11 a_309_21# B 0.13668f
C12 VPWR VPB 0.124f
C13 a_73_297# VGND 0.00122f
C14 VPWR B 0.05497f
C15 a_309_21# Y 0.04647f
C16 a_73_297# VPB 0.01107f
C17 VPWR Y 0.04588f
C18 a_309_21# VPWR 0.06243f
C19 a_73_297# B 0.0162f
C20 VGND A 0.06054f
C21 a_527_297# A 0.00618f
C22 A VPB 0.09498f
C23 a_73_297# Y 0.07433f
C24 a_309_21# a_73_297# 0.00687f
C25 B A 0.13203f
C26 a_73_297# VPWR 0.10246f
C27 A Y 0.09864f
C28 a_309_21# A 0.20797f
C29 VGND a_155_47# 0.01038f
C30 VGND a_527_297# 0
C31 VPWR A 0.15691f
C32 VGND VPB 0.00883f
C33 B a_155_47# 0.00361f
C34 VGND B 0.1076f
C35 B a_527_297# 0
C36 a_73_297# A 0.05069f
C37 B VPB 0.07084f
C38 VGND VNB 0.56901f
C39 Y VNB 0.17367f
C40 VPWR VNB 0.35553f
C41 VPB VNB 0.78196f
C42 a_527_297# VNB 0.1173f
C43 a_73_297# VNB 0.19015f
C44 Y.t1 VNB 0.01669f
C45 Y.t2 VNB 0.01669f
C46 Y.t0 VNB 0.26564f
C47 Y.n0 VNB 0.04866f
C48 Y.n1 VNB 0.11844f
C49 Y.n2 VNB 0.03409f
C50 Y.n3 VNB 0.0583f
.ends
