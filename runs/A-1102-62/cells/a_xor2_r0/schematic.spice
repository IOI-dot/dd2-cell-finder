.subckt a_xor2_r0 A B VGND VNB VPB VPWR Y
X0 _s1 A VGND VNB sky130_fd_pr__nfet_01v8 w=650000u l=150000u
X1 _s1 B VGND VNB sky130_fd_pr__nfet_01v8 w=650000u l=150000u
X2 Y _s1 VGND VNB sky130_fd_pr__nfet_01v8 w=650000u l=150000u
X3 Y A n1 VNB sky130_fd_pr__nfet_01v8 w=650000u l=150000u
X4 n1 B VGND VNB sky130_fd_pr__nfet_01v8 w=650000u l=150000u
X5 _s1 A p1 VPB sky130_fd_pr__pfet_01v8_hvt w=1000000u l=150000u
X6 p1 B VPWR VPB sky130_fd_pr__pfet_01v8_hvt w=1000000u l=150000u
X7 Y _s1 p2 VPB sky130_fd_pr__pfet_01v8_hvt w=1000000u l=150000u
X8 p2 A VPWR VPB sky130_fd_pr__pfet_01v8_hvt w=1000000u l=150000u
X9 p2 B VPWR VPB sky130_fd_pr__pfet_01v8_hvt w=1000000u l=150000u
.ends
