* NGSPICE file created from a_xor2_r3.ext - technology: sky130A

.subckt a_xor2_r3 A B VGND VNB VPB VPWR Y
X0 VPWR A a_147_297# VPB sky130_fd_pr__pfet_01v8_hvt ad=0.175 pd=1.35 as=0.175 ps=1.35 w=1 l=0.15 sa=0.76 sb=0.76
X1 a_535_297# B VPWR VPB sky130_fd_pr__pfet_01v8_hvt ad=0.135 pd=1.27 as=0.26 ps=2.52 w=1 l=0.15 sa=0.26 sb=0.68
X2 a_247_47# A Y.t2 VNB sky130_fd_pr__nfet_01v8 ad=0.11375 pd=1 as=0.11375 ps=1 w=0.65 l=0.15 sa=0.76 sb=2.12
X3 a_93_199# B VGND VNB sky130_fd_pr__nfet_01v8 ad=0.08775 pd=0.92 as=0.25675 ps=1.44 w=0.65 l=0.15 sa=2.2 sb=0.68
X4 Y.t1 a_93_199# VGND VNB sky130_fd_pr__nfet_01v8 ad=0.11375 pd=1 as=0.169 ps=1.82 w=0.65 l=0.15 sa=0.26 sb=2.62
X5 a_147_297# a_93_199# Y.t0 VPB sky130_fd_pr__pfet_01v8_hvt ad=0.175 pd=1.35 as=0.26 ps=2.52 w=1 l=0.15 sa=0.26 sb=1.26
X6 VGND A a_93_199# VNB sky130_fd_pr__nfet_01v8 ad=0.169 pd=1.82 as=0.08775 ps=0.92 w=0.65 l=0.15 sa=2.62 sb=0.26
X7 a_93_199# A a_535_297# VPB sky130_fd_pr__pfet_01v8_hvt ad=0.26 pd=2.52 as=0.135 ps=1.27 w=1 l=0.15 sa=0.68 sb=0.26
X8 a_147_297# B VPWR VPB sky130_fd_pr__pfet_01v8_hvt ad=0.26 pd=2.52 as=0.175 ps=1.35 w=1 l=0.15 sa=1.26 sb=0.26
X9 VGND B a_247_47# VNB sky130_fd_pr__nfet_01v8 ad=0.25675 pd=1.44 as=0.11375 ps=1 w=0.65 l=0.15 sa=1.26 sb=1.62
R0 Y.n0 Y.t0 228.772
R1 Y.n3 Y.n2 197.8
R2 Y.n2 Y.n1 185
R3 Y.n1 Y.n0 106.918
R4 Y.n2 Y.t1 32.3082
R5 Y.n2 Y.t2 32.3082
R6 Y.n3 Y 6.4005
R7 Y.n1 Y 6.4005
R8 Y.n0 Y 3.29747
R9 Y Y.n3 2.25932
C0 A B 0.1262f
C1 a_147_297# Y 0.03114f
C2 B VPWR 0.03997f
C3 a_93_199# B 0.04452f
C4 VGND a_247_47# 0.01323f
C5 VGND a_535_297# 0
C6 Y B 0.00363f
C7 VGND VPB 0.00778f
C8 A a_247_47# 0.00231f
C9 VGND A 0.04956f
C10 A a_535_297# 0.00719f
C11 a_147_297# B 0.01506f
C12 A VPB 0.07972f
C13 VPWR a_247_47# 0
C14 a_93_199# a_247_47# 0.00549f
C15 VGND VPWR 0.01466f
C16 a_93_199# VGND 0.20918f
C17 a_535_297# VPWR 0.01427f
C18 a_93_199# a_535_297# 0.00869f
C19 VPWR VPB 0.11728f
C20 Y a_247_47# 0.00537f
C21 a_93_199# VPB 0.06036f
C22 Y VGND 0.0694f
C23 Y a_535_297# 0
C24 A VPWR 0.06041f
C25 a_93_199# A 0.13881f
C26 Y VPB 0.02175f
C27 a_147_297# a_535_297# 0
C28 Y A 0.01882f
C29 a_93_199# VPWR 0.0933f
C30 a_147_297# VPB 0.01058f
C31 B a_247_47# 0.00229f
C32 Y VPWR 0.03506f
C33 a_93_199# Y 0.10176f
C34 a_147_297# A 0.05338f
C35 VGND B 0.04447f
C36 B VPB 0.0929f
C37 a_147_297# VPWR 0.1208f
C38 a_93_199# a_147_297# 0.01494f
C39 VGND VNB 0.56925f
C40 VPWR VNB 0.51147f
C41 Y VNB 0.08507f
C42 VPB VNB 0.78196f
C43 a_535_297# VNB 0.08691f
C44 a_147_297# VNB 0.07515f
C45 Y.t2 VNB 0.01354f
C46 Y.t1 VNB 0.11839f
C47 Y.t0 VNB 0.0587f
C48 Y.n0 VNB 0.10029f
C49 Y.n1 VNB 0.03583f
C50 Y.n2 VNB 0.02752f
C51 Y.n3 VNB 0.03648f
.ends
