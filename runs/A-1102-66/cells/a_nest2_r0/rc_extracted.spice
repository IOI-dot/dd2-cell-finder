* NGSPICE file created from a_nest2_r0.ext - technology: sky130A

.subckt a_nest2_r0 A B C D VGND VNB VPB VPWR Y
X0 a_149_297# C a_349_297# VPB sky130_fd_pr__pfet_01v8_hvt ad=0.26 pd=2.52 as=0.135 ps=1.27 w=1 l=0.15 sa=1.68 sb=0.26
X1 a_249_47# B Y.t2 VNB sky130_fd_pr__nfet_01v8 ad=0.11375 pd=1 as=0.11375 ps=1 w=0.65 l=0.15 sa=0.76 sb=1.18
X2 a_349_297# D VPWR VPB sky130_fd_pr__pfet_01v8_hvt ad=0.135 pd=1.27 as=0.175 ps=1.35 w=1 l=0.15 sa=1.26 sb=0.68
X3 Y.t1 A VGND VNB sky130_fd_pr__nfet_01v8 ad=0.11375 pd=1 as=0.169 ps=1.82 w=0.65 l=0.15 sa=0.26 sb=1.68
X4 VPWR B a_149_297# VPB sky130_fd_pr__pfet_01v8_hvt ad=0.175 pd=1.35 as=0.175 ps=1.35 w=1 l=0.15 sa=0.76 sb=1.18
X5 a_249_47# C VGND VNB sky130_fd_pr__nfet_01v8 ad=0.169 pd=1.82 as=0.08775 ps=0.92 w=0.65 l=0.15 sa=1.68 sb=0.26
X6 a_149_297# A Y.t0 VPB sky130_fd_pr__pfet_01v8_hvt ad=0.175 pd=1.35 as=0.26 ps=2.52 w=1 l=0.15 sa=0.26 sb=1.68
X7 VGND D a_249_47# VNB sky130_fd_pr__nfet_01v8 ad=0.08775 pd=0.92 as=0.11375 ps=1 w=0.65 l=0.15 sa=1.26 sb=0.68
R0 Y.n0 Y 587.092
R1 Y.n1 Y.n0 290.423
R2 Y.n4 Y.n3 185
R3 Y.n3 Y.n2 185
R4 Y.n2 Y.n1 106.766
R5 Y.n3 Y.t1 32.3082
R6 Y.n3 Y.t2 32.3082
R7 Y.n0 Y.t0 26.5955
R8 Y Y.n5 20.4005
R9 Y.n5 Y.n4 12.8005
R10 Y.n5 Y.n2 12.8005
R11 Y.n1 Y 10.4328
R12 Y.n4 Y 6.4005
C0 B A 0.03085f
C1 B VPWR 0.01627f
C2 VGND A 0.01745f
C3 a_349_297# a_249_47# 0.00133f
C4 VGND VPWR 0.03005f
C5 C a_249_47# 0.02741f
C6 VPWR A 0.01466f
C7 VPB a_149_297# 0.02478f
C8 Y a_249_47# 0.02361f
C9 D a_149_297# 0.02271f
C10 C a_349_297# 0
C11 B VPB 0.02917f
C12 C Y 0
C13 D B 0.03085f
C14 VGND VPB 0.01012f
C15 A VPB 0.03386f
C16 VPWR VPB 0.08134f
C17 VGND D 0.01669f
C18 D VPWR 0.01711f
C19 a_149_297# a_249_47# 0.00695f
C20 B a_249_47# 0.00605f
C21 a_349_297# a_149_297# 0.01661f
C22 C a_149_297# 0.02741f
C23 VGND a_249_47# 0.09829f
C24 VPWR a_249_47# 0.00357f
C25 D VPB 0.02804f
C26 Y a_149_297# 0.03938f
C27 VGND a_349_297# 0.00176f
C28 VGND C 0.01525f
C29 B Y 0.01309f
C30 VPWR a_349_297# 0.00927f
C31 C VPWR 0.01248f
C32 VGND Y 0.06623f
C33 Y A 0.0569f
C34 VPWR Y 0.04674f
C35 VPB a_249_47# 0.0021f
C36 D a_249_47# 0.02764f
C37 C VPB 0.03194f
C38 B a_149_297# 0.02766f
C39 D a_349_297# 0
C40 C D 0.03192f
C41 VGND a_149_297# 0.00516f
C42 Y VPB 0.02306f
C43 A a_149_297# 0.00792f
C44 VPWR a_149_297# 0.11377f
C45 D Y 0
C46 VGND B 0.01742f
C47 VGND VNB 0.40677f
C48 VPWR VNB 0.31231f
C49 Y VNB 0.14056f
C50 VPB VNB 0.60476f
C51 a_249_47# VNB 0.06044f
C52 a_349_297# VNB 0.07293f
C53 a_149_297# VNB 0.07886f
C54 Y.t0 VNB 0.01361f
C55 Y.n0 VNB 0.03887f
C56 Y.n1 VNB 0.06751f
C57 Y.n2 VNB 0.03253f
C58 Y.t2 VNB 0.03996f
C59 Y.t1 VNB 0.05289f
C60 Y.n3 VNB 0.02294f
C61 Y.n4 VNB 0.00437f
C62 Y.n5 VNB 0.01817f
.ends
