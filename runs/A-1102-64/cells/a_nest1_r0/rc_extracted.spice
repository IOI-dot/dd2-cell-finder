* NGSPICE file created from a_nest1_r0.ext - technology: sky130A

.subckt a_nest1_r0 A B C D VGND VNB VPB VPWR Y
X0 a_249_297# C VPWR VPB sky130_fd_pr__pfet_01v8_hvt ad=0.26 pd=2.52 as=0.135 ps=1.27 w=1 l=0.15 sa=1.68 sb=0.26
X1 VGND B a_149_47# VNB sky130_fd_pr__nfet_01v8 ad=0.11375 pd=1 as=0.11375 ps=1 w=0.65 l=0.15 sa=0.76 sb=1.18
X2 VPWR D a_249_297# VPB sky130_fd_pr__pfet_01v8_hvt ad=0.135 pd=1.27 as=0.175 ps=1.35 w=1 l=0.15 sa=1.26 sb=0.68
X3 a_149_47# A Y VNB sky130_fd_pr__nfet_01v8 ad=0.11375 pd=1 as=0.169 ps=1.82 w=0.65 l=0.15 sa=0.26 sb=1.68
X4 a_249_297# B Y VPB sky130_fd_pr__pfet_01v8_hvt ad=0.175 pd=1.35 as=0.175 ps=1.35 w=1 l=0.15 sa=0.76 sb=1.18
X5 a_149_47# C a_349_47# VNB sky130_fd_pr__nfet_01v8 ad=0.169 pd=1.82 as=0.08775 ps=0.92 w=0.65 l=0.15 sa=1.68 sb=0.26
X6 Y A VPWR VPB sky130_fd_pr__pfet_01v8_hvt ad=0.175 pd=1.35 as=0.26 ps=2.52 w=1 l=0.15 sa=0.26 sb=1.68
X7 a_349_47# D VGND VNB sky130_fd_pr__nfet_01v8 ad=0.08775 pd=0.92 as=0.11375 ps=1 w=0.65 l=0.15 sa=1.26 sb=0.68
C0 VPWR B 0.01692f
C1 Y a_149_47# 0.02486f
C2 Y A 0.05245f
C3 a_149_47# C 0.02697f
C4 VGND A 0.0154f
C5 VGND a_149_47# 0.10029f
C6 Y VPB 0.02258f
C7 VPB C 0.03194f
C8 VGND VPB 0.01104f
C9 VPWR a_249_297# 0.10998f
C10 a_149_47# D 0.02502f
C11 VPB D 0.02778f
C12 a_149_47# B 0.02666f
C13 B A 0.03085f
C14 B VPB 0.03007f
C15 a_349_47# VPWR 0
C16 a_149_47# a_249_297# 0.00784f
C17 VPB a_249_297# 0.01505f
C18 VPWR A 0.01813f
C19 a_149_47# VPWR 0.00453f
C20 VPWR VPB 0.08816f
C21 a_349_47# a_149_47# 0.01025f
C22 Y C 0
C23 VGND Y 0.04506f
C24 VGND C 0.01305f
C25 Y D 0
C26 a_149_47# A 0.00499f
C27 D C 0.03192f
C28 VGND D 0.01634f
C29 A VPB 0.03355f
C30 a_149_47# VPB 0.00206f
C31 Y B 0.01531f
C32 VGND B 0.0165f
C33 B D 0.03085f
C34 Y a_249_297# 0.03597f
C35 a_249_297# C 0.02829f
C36 VGND a_249_297# 0.00438f
C37 Y VPWR 0.07685f
C38 a_249_297# D 0.02843f
C39 VPWR C 0.01494f
C40 VGND VPWR 0.03062f
C41 VPWR D 0.01645f
C42 B a_249_297# 0.00847f
C43 VGND a_349_47# 0.00793f
C44 VGND VNB 0.37535f
C45 Y VNB 0.13632f
C46 VPWR VNB 0.36686f
C47 VPB VNB 0.60476f
C48 a_149_47# VNB 0.10517f
C49 a_249_297# VNB 0.10371f
.ends
