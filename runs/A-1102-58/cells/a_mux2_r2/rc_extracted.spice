* NGSPICE file created from a_mux2_r2.ext - technology: sky130A

.subckt a_mux2_r2 A B C VGND VNB VPB VPWR Y
X0 a_253_297# A a_431_47# VPB sky130_fd_pr__pfet_01v8_hvt ad=0.26 pd=2.52 as=0.135 ps=1.27 w=1 l=0.15 sa=1.66 sb=0.26
X1 Y a_431_47# VGND VNB sky130_fd_pr__nfet_01v8 ad=0.169 pd=1.82 as=0.25675 ps=1.44 w=0.65 l=0.15 sa=3.54 sb=0.26
X2 Y a_431_47# VPWR VPB sky130_fd_pr__pfet_01v8_hvt ad=0.26 pd=2.52 as=0.26 ps=2.52 w=1 l=0.15 sa=0.26 sb=0.26
X3 VGND C a_65_47# VNB sky130_fd_pr__nfet_01v8 ad=0.25675 pd=1.44 as=0.169 ps=1.82 w=0.65 l=0.15 sa=0.26 sb=3.54
X4 VPWR C a_65_47# VPB sky130_fd_pr__pfet_01v8_hvt ad=0.26 pd=2.52 as=0.26 ps=2.52 w=1 l=0.15 sa=0.26 sb=0.26
X5 a_431_47# a_65_47# a_253_297# VPB sky130_fd_pr__pfet_01v8_hvt ad=0.135 pd=1.27 as=0.175 ps=1.35 w=1 l=0.15 sa=1.24 sb=0.68
X6 a_531_47# a_65_47# a_431_47# VNB sky130_fd_pr__nfet_01v8 ad=0.08775 pd=0.92 as=0.11375 ps=1 w=0.65 l=0.15 sa=2.18 sb=1.62
X7 a_431_47# B a_335_47# VNB sky130_fd_pr__nfet_01v8 ad=0.11375 pd=1 as=0.10725 ps=0.98 w=0.65 l=0.15 sa=1.68 sb=2.12
X8 a_253_297# B VPWR VPB sky130_fd_pr__pfet_01v8_hvt ad=0.175 pd=1.35 as=0.165 ps=1.33 w=1 l=0.15 sa=0.74 sb=1.18
X9 VGND A a_531_47# VNB sky130_fd_pr__nfet_01v8 ad=0.25675 pd=1.44 as=0.08775 ps=0.92 w=0.65 l=0.15 sa=2.6 sb=1.2
X10 VPWR C a_253_297# VPB sky130_fd_pr__pfet_01v8_hvt ad=0.165 pd=1.33 as=0.26 ps=2.52 w=1 l=0.15 sa=0.26 sb=1.66
X11 a_335_47# C VGND VNB sky130_fd_pr__nfet_01v8 ad=0.10725 pd=0.98 as=0.25675 ps=1.44 w=0.65 l=0.15 sa=1.2 sb=2.6
C0 B VGND 0.01982f
C1 a_531_47# VGND 0.0077f
C2 B a_335_47# 0.00229f
C3 a_335_47# VGND 0.01371f
C4 a_253_297# Y 0
C5 a_431_47# Y 0.05133f
C6 C a_65_47# 0.08614f
C7 a_253_297# VPWR 0.19815f
C8 B a_65_47# 0.05222f
C9 a_431_47# VPWR 0.04474f
C10 C VPB 0.09844f
C11 A VGND 0.01532f
C12 B VPB 0.02789f
C13 a_65_47# VGND 0.08545f
C14 a_335_47# a_65_47# 0.0018f
C15 VPB VGND 0.01659f
C16 VPWR Y 0.05942f
C17 A a_65_47# 0.03357f
C18 C a_253_297# 0.01406f
C19 B a_253_297# 0.01305f
C20 C a_431_47# 0.00323f
C21 A VPB 0.03134f
C22 B a_431_47# 0.00686f
C23 VPB a_65_47# 0.06631f
C24 a_431_47# a_531_47# 0.00928f
C25 a_253_297# VGND 0.00538f
C26 a_431_47# VGND 0.11513f
C27 a_335_47# a_431_47# 0.0051f
C28 C Y 0
C29 B Y 0
C30 a_531_47# Y 0
C31 C VPWR 0.03901f
C32 B VPWR 0.01592f
C33 VGND Y 0.04239f
C34 A a_253_297# 0.01356f
C35 A a_431_47# 0.06925f
C36 a_253_297# a_65_47# 0.07848f
C37 VPWR a_531_47# 0
C38 a_431_47# a_65_47# 0.04589f
C39 VPWR VGND 0.05286f
C40 VPB a_253_297# 0.01342f
C41 VPB a_431_47# 0.05781f
C42 a_335_47# VPWR 0.00149f
C43 A Y 0
C44 a_65_47# Y 0
C45 A VPWR 0.01026f
C46 VPB Y 0.01872f
C47 a_65_47# VPWR 0.10013f
C48 B C 0.03175f
C49 VPB VPWR 0.14595f
C50 a_253_297# a_431_47# 0.03814f
C51 C VGND 0.05205f
C52 VGND VNB 0.70905f
C53 Y VNB 0.15961f
C54 VPWR VNB 0.42911f
C55 VPB VNB 0.95915f
C56 a_335_47# VNB 0.02833f
C57 a_253_297# VNB 0.16011f
C58 a_431_47# VNB 0.15606f
.ends
