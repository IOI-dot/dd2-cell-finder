* NGSPICE file created from a_mux2_r3.ext - technology: sky130A

.subckt a_mux2_r3 A B C VGND VNB VPB VPWR Y
X0 VPWR C a_233_297# VPB sky130_fd_pr__pfet_01v8_hvt ad=0.285 pd=1.57 as=0.26 ps=2.52 w=1 l=0.15 sa=0.26 sb=2.32
X1 VPWR a_97_21# Y VPB sky130_fd_pr__pfet_01v8_hvt ad=0.26 pd=2.52 as=0.26 ps=2.52 w=1 l=0.15 sa=0.26 sb=0.26
X2 a_529_199# C VPWR VPB sky130_fd_pr__pfet_01v8_hvt ad=0.26 pd=2.52 as=0.26 ps=2.52 w=1 l=0.15 sa=0.26 sb=0.26
X3 a_583_47# a_529_199# a_97_21# VNB sky130_fd_pr__nfet_01v8 ad=0.18525 pd=1.22 as=0.15275 ps=1.12 w=0.65 l=0.15 sa=2.54 sb=1.92
X4 VGND a_97_21# Y VNB sky130_fd_pr__nfet_01v8 ad=0.25675 pd=1.44 as=0.169 ps=1.82 w=0.65 l=0.15 sa=0.26 sb=4.2
X5 a_97_21# a_529_199# a_233_297# VPB sky130_fd_pr__pfet_01v8_hvt ad=0.285 pd=1.57 as=0.235 ps=1.47 w=1 l=0.15 sa=1.6 sb=0.98
X6 a_315_47# C VGND VNB sky130_fd_pr__nfet_01v8 ad=0.18525 pd=1.22 as=0.25675 ps=1.44 w=0.65 l=0.15 sa=1.2 sb=3.26
X7 VGND A a_583_47# VNB sky130_fd_pr__nfet_01v8 ad=0.25675 pd=1.44 as=0.18525 ps=1.22 w=0.65 l=0.15 sa=3.26 sb=1.2
X8 a_233_297# B VPWR VPB sky130_fd_pr__pfet_01v8_hvt ad=0.235 pd=1.47 as=0.285 ps=1.57 w=1 l=0.15 sa=0.98 sb=1.6
X9 a_97_21# B a_315_47# VNB sky130_fd_pr__nfet_01v8 ad=0.15275 pd=1.12 as=0.18525 ps=1.22 w=0.65 l=0.15 sa=1.92 sb=2.54
X10 a_233_297# A a_97_21# VPB sky130_fd_pr__pfet_01v8_hvt ad=0.26 pd=2.52 as=0.285 ps=1.57 w=1 l=0.15 sa=2.32 sb=0.26
X11 a_529_199# C VGND VNB sky130_fd_pr__nfet_01v8 ad=0.169 pd=1.82 as=0.25675 ps=1.44 w=0.65 l=0.15 sa=4.2 sb=0.26
C0 C VPWR 0.03456f
C1 B VPWR 0.01583f
C2 a_583_47# VPWR 0.00139f
C3 C Y 0.00254f
C4 B Y 0
C5 VGND VPWR 0.05776f
C6 A a_233_297# 0.0077f
C7 A a_529_199# 0.03006f
C8 a_233_297# a_97_21# 0.04853f
C9 a_529_199# a_97_21# 0.09577f
C10 a_315_47# VPWR 0.0013f
C11 Y VGND 0.04827f
C12 VPB a_233_297# 0.01562f
C13 VPB a_529_199# 0.06544f
C14 A VPWR 0.01045f
C15 a_97_21# VPWR 0.05468f
C16 VPB VPWR 0.14485f
C17 a_97_21# Y 0.03959f
C18 B C 0.01926f
C19 C a_583_47# 0.01565f
C20 VPB Y 0.01704f
C21 a_233_297# a_529_199# 0.09093f
C22 C VGND 0.2384f
C23 B VGND 0.0101f
C24 C a_315_47# 0.01578f
C25 a_583_47# VGND 0.00597f
C26 B a_315_47# 0
C27 a_315_47# VGND 0.00577f
C28 a_233_297# VPWR 0.21968f
C29 a_529_199# VPWR 0.09223f
C30 C A 0.04021f
C31 C a_97_21# 0.15695f
C32 a_233_297# Y 0.00171f
C33 B a_97_21# 0.03368f
C34 a_529_199# Y 0.00137f
C35 A a_583_47# 0
C36 C VPB 0.07383f
C37 a_97_21# a_583_47# 0.00889f
C38 A VGND 0.01162f
C39 B VPB 0.03345f
C40 a_97_21# VGND 0.06149f
C41 a_315_47# a_97_21# 0.00937f
C42 VPB VGND 0.01281f
C43 Y VPWR 0.06081f
C44 A a_97_21# 0.01701f
C45 C a_233_297# 0.01433f
C46 B a_233_297# 0.02284f
C47 C a_529_199# 0.07874f
C48 A VPB 0.03649f
C49 B a_529_199# 0.03145f
C50 VPB a_97_21# 0.06331f
C51 a_529_199# a_583_47# 0
C52 a_233_297# VGND 0.00737f
C53 a_529_199# VGND 0.0535f
C54 a_315_47# a_233_297# 0
C55 VGND VNB 0.65735f
C56 VPWR VNB 0.65585f
C57 Y VNB 0.19131f
C58 VPB VNB 1.04774f
C59 a_583_47# VNB 0.11537f
C60 a_233_297# VNB 0.12647f
.ends
