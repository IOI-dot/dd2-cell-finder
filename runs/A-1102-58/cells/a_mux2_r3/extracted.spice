* NGSPICE file created from a_mux2_r3.ext - technology: sky130A

.subckt a_mux2_r3 A B C VGND VNB VPB VPWR Y
X0 VPWR C a_233_297# VPB sky130_fd_pr__pfet_01v8_hvt ad=0.285 pd=1.57 as=0.26 ps=2.52 w=1 l=0.15
X1 VPWR a_97_21# Y VPB sky130_fd_pr__pfet_01v8_hvt ad=0.26 pd=2.52 as=0.26 ps=2.52 w=1 l=0.15
X2 a_529_199# C VPWR VPB sky130_fd_pr__pfet_01v8_hvt ad=0.26 pd=2.52 as=0.26 ps=2.52 w=1 l=0.15
X3 a_583_47# a_529_199# a_97_21# VNB sky130_fd_pr__nfet_01v8 ad=0.18525 pd=1.22 as=0.15275 ps=1.12 w=0.65 l=0.15
X4 VGND a_97_21# Y VNB sky130_fd_pr__nfet_01v8 ad=0.25675 pd=1.44 as=0.169 ps=1.82 w=0.65 l=0.15
X5 a_97_21# a_529_199# a_233_297# VPB sky130_fd_pr__pfet_01v8_hvt ad=0.285 pd=1.57 as=0.235 ps=1.47 w=1 l=0.15
X6 a_315_47# C VGND VNB sky130_fd_pr__nfet_01v8 ad=0.18525 pd=1.22 as=0.25675 ps=1.44 w=0.65 l=0.15
X7 VGND A a_583_47# VNB sky130_fd_pr__nfet_01v8 ad=0.25675 pd=1.44 as=0.18525 ps=1.22 w=0.65 l=0.15
X8 a_233_297# B VPWR VPB sky130_fd_pr__pfet_01v8_hvt ad=0.235 pd=1.47 as=0.285 ps=1.57 w=1 l=0.15
X9 a_97_21# B a_315_47# VNB sky130_fd_pr__nfet_01v8 ad=0.15275 pd=1.12 as=0.18525 ps=1.22 w=0.65 l=0.15
X10 a_233_297# A a_97_21# VPB sky130_fd_pr__pfet_01v8_hvt ad=0.26 pd=2.52 as=0.285 ps=1.57 w=1 l=0.15
X11 a_529_199# C VGND VNB sky130_fd_pr__nfet_01v8 ad=0.169 pd=1.82 as=0.25675 ps=1.44 w=0.65 l=0.15
.ends
