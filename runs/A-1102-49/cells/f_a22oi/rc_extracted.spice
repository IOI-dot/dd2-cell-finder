* NGSPICE file created from f_a22oi.ext - technology: sky130A

.subckt f_a22oi A B C D VGND VNB VPB VPWR Y
X0 a_59_297# A Y VPB sky130_fd_pr__pfet_01v8_hvt ad=0.175 pd=1.35 as=0.175 ps=1.35 w=1 l=0.15 sa=0.76 sb=1.26
X1 a_341_47# C Y VNB sky130_fd_pr__nfet_01v8 ad=0.11375 pd=1 as=0.11375 ps=1 w=0.65 l=0.15 sa=1.26 sb=0.76
X2 Y B a_59_297# VPB sky130_fd_pr__pfet_01v8_hvt ad=0.175 pd=1.35 as=0.26 ps=2.52 w=1 l=0.15 sa=0.26 sb=1.76
X3 Y A a_141_47# VNB sky130_fd_pr__nfet_01v8 ad=0.11375 pd=1 as=0.11375 ps=1 w=0.65 l=0.15 sa=0.76 sb=1.26
X4 a_59_297# D VPWR VPB sky130_fd_pr__pfet_01v8_hvt ad=0.26 pd=2.52 as=0.175 ps=1.35 w=1 l=0.15 sa=1.76 sb=0.26
X5 a_141_47# B VGND VNB sky130_fd_pr__nfet_01v8 ad=0.11375 pd=1 as=0.169 ps=1.82 w=0.65 l=0.15 sa=0.26 sb=1.76
X6 VPWR C a_59_297# VPB sky130_fd_pr__pfet_01v8_hvt ad=0.175 pd=1.35 as=0.175 ps=1.35 w=1 l=0.15 sa=1.26 sb=0.76
X7 VGND D a_341_47# VNB sky130_fd_pr__nfet_01v8 ad=0.169 pd=1.82 as=0.11375 ps=1 w=0.65 l=0.15 sa=1.76 sb=0.26
C0 VPWR D 0.0145f
C1 VGND VPWR 0.02983f
C2 VGND D 0.01659f
C3 VPWR C 0.01538f
C4 a_141_47# B 0
C5 C D 0.03085f
C6 VGND C 0.01406f
C7 B VPB 0.03326f
C8 VPWR A 0.00959f
C9 VGND A 0.02104f
C10 A C 0.03085f
C11 VPWR a_59_297# 0.16808f
C12 a_59_297# D 0.01281f
C13 VGND a_59_297# 0.00848f
C14 VPWR Y 0.02043f
C15 a_59_297# C 0.01345f
C16 Y D 0.05639f
C17 VGND Y 0.08044f
C18 Y C 0.04787f
C19 A a_59_297# 0.01404f
C20 VPWR a_341_47# 0.00115f
C21 VGND a_341_47# 0.01081f
C22 Y A 0.0289f
C23 VPWR a_141_47# 0.00158f
C24 VPWR B 0.0094f
C25 VGND a_141_47# 0.0158f
C26 VGND B 0.03013f
C27 VPWR VPB 0.07865f
C28 VPB D 0.03234f
C29 VGND VPB 0.01213f
C30 Y a_59_297# 0.09825f
C31 VPB C 0.0282f
C32 A B 0.03085f
C33 a_141_47# A 0.00229f
C34 A VPB 0.0282f
C35 a_341_47# Y 0.01189f
C36 a_141_47# a_59_297# 0
C37 B a_59_297# 0.02595f
C38 VPB a_59_297# 0.02149f
C39 a_141_47# Y 0.00647f
C40 Y B 0.00571f
C41 Y VPB 0.01829f
C42 VGND VNB 0.39233f
C43 VPWR VNB 0.32737f
C44 Y VNB 0.17365f
C45 VPB VNB 0.60476f
C46 a_341_47# VNB 0.02842f
C47 a_59_297# VNB 0.16355f
.ends
