* NGSPICE file created from a_nand3_r1.ext - technology: sky130A

.subckt a_nand3_r1 A B C VGND VNB VPB VPWR Y
X0 Y C VPWR VPB sky130_fd_pr__pfet_01v8_hvt ad=0.555 pd=2.11 as=0.26 ps=2.52 w=1 l=0.15
X1 Y A a_373_47# VNB sky130_fd_pr__nfet_01v8 ad=0.169 pd=1.82 as=0.08775 ps=0.92 w=0.65 l=0.15
X2 VPWR B Y VPB sky130_fd_pr__pfet_01v8_hvt ad=0.645 pd=2.29 as=0.555 ps=2.11 w=1 l=0.15
X3 Y A VPWR VPB sky130_fd_pr__pfet_01v8_hvt ad=0.26 pd=2.52 as=0.645 ps=2.29 w=1 l=0.15
X4 VGND C a_121_47# VNB sky130_fd_pr__nfet_01v8 ad=0.08775 pd=0.92 as=0.08775 ps=0.92 w=0.65 l=0.15
X5 a_121_47# C VGND VNB sky130_fd_pr__nfet_01v8 ad=0.08775 pd=0.92 as=0.169 ps=1.82 w=0.65 l=0.15
X6 a_373_47# B a_121_47# VNB sky130_fd_pr__nfet_01v8 ad=0.08775 pd=0.92 as=0.08775 ps=0.92 w=0.65 l=0.15
X7 a_373_47# B a_121_47# VNB sky130_fd_pr__nfet_01v8 ad=0.14625 pd=1.1 as=0.08775 ps=0.92 w=0.65 l=0.15
X8 Y A a_373_47# VNB sky130_fd_pr__nfet_01v8 ad=0.08775 pd=0.92 as=0.14625 ps=1.1 w=0.65 l=0.15
X9 a_121_47# C VGND VNB sky130_fd_pr__nfet_01v8 ad=0.08775 pd=0.92 as=0.08775 ps=0.92 w=0.65 l=0.15
X10 a_121_47# B a_373_47# VNB sky130_fd_pr__nfet_01v8 ad=0.08775 pd=0.92 as=0.08775 ps=0.92 w=0.65 l=0.15
X11 a_373_47# A Y VNB sky130_fd_pr__nfet_01v8 ad=0.08775 pd=0.92 as=0.08775 ps=0.92 w=0.65 l=0.15
.ends
