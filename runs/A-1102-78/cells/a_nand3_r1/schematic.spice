.subckt a_nand3_r1 A B C VGND VNB VPB VPWR Y
X0 Y A n1 VNB sky130_fd_pr__nfet_01v8 w=650000u l=150000u
X1 Y A n1 VNB sky130_fd_pr__nfet_01v8 w=650000u l=150000u
X2 Y A n1 VNB sky130_fd_pr__nfet_01v8 w=650000u l=150000u
X3 n1 B n2 VNB sky130_fd_pr__nfet_01v8 w=650000u l=150000u
X4 n1 B n2 VNB sky130_fd_pr__nfet_01v8 w=650000u l=150000u
X5 n1 B n2 VNB sky130_fd_pr__nfet_01v8 w=650000u l=150000u
X6 n2 C VGND VNB sky130_fd_pr__nfet_01v8 w=650000u l=150000u
X7 n2 C VGND VNB sky130_fd_pr__nfet_01v8 w=650000u l=150000u
X8 n2 C VGND VNB sky130_fd_pr__nfet_01v8 w=650000u l=150000u
X9 Y A VPWR VPB sky130_fd_pr__pfet_01v8_hvt w=1000000u l=150000u
X10 Y B VPWR VPB sky130_fd_pr__pfet_01v8_hvt w=1000000u l=150000u
X11 Y C VPWR VPB sky130_fd_pr__pfet_01v8_hvt w=1000000u l=150000u
.ends
