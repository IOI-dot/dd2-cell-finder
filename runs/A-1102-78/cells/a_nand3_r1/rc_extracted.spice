* NGSPICE file created from a_nand3_r1.ext - technology: sky130A

.subckt a_nand3_r1 A B C VGND VNB VPB VPWR Y
X0 Y.t4 C.t3 VPWR.t1 VPB.t1 sky130_fd_pr__pfet_01v8_hvt ad=0.555 pd=2.11 as=0.26 ps=2.52 w=1 l=0.15 sa=0.26 sb=2.96
X1 Y.t0 A.t0 a_373_47.t2 VNB.t2 sky130_fd_pr__nfet_01v8 ad=0.169 pd=1.82 as=0.08775 ps=0.92 w=0.65 l=0.15 sa=2.96 sb=1.1
X2 VPWR.t0 B.t3 Y.t2 VPB.t2 sky130_fd_pr__pfet_01v8_hvt ad=0.645 pd=2.29 as=0.555 ps=2.11 w=1 l=0.15 sa=1.52 sb=1.7
X3 Y.t5 A.t3 VPWR.t2 VPB.t0 sky130_fd_pr__pfet_01v8_hvt ad=0.26 pd=2.52 as=0.645 ps=2.29 w=1 l=0.15 sa=2.96 sb=0.26
X4 VGND.t1 C.t1 a_121_47.t1 VNB.t4 sky130_fd_pr__nfet_01v8 ad=0.08775 pd=0.92 as=0.08775 ps=0.92 w=0.65 l=0.15 sa=0.26 sb=3.8
X5 a_121_47.t0 C.t2 VGND.t2 VNB.t3 sky130_fd_pr__nfet_01v8 ad=0.08775 pd=0.92 as=0.169 ps=1.82 w=0.65 l=0.15 sa=0.68 sb=3.38
X6 a_373_47.t3 B.t2 a_121_47.t3 VNB.t6 sky130_fd_pr__nfet_01v8 ad=0.08775 pd=0.92 as=0.08775 ps=0.92 w=0.65 l=0.15 sa=1.52 sb=2.54
X7 a_373_47.t4 B.t0 a_121_47.t5 VNB.t8 sky130_fd_pr__nfet_01v8 ad=0.14625 pd=1.1 as=0.08775 ps=0.92 w=0.65 l=0.15 sa=1.94 sb=2.12
X8 Y.t1 A.t2 a_373_47.t0 VNB.t0 sky130_fd_pr__nfet_01v8 ad=0.08775 pd=0.92 as=0.14625 ps=1.1 w=0.65 l=0.15 sa=3.38 sb=0.68
X9 a_121_47.t2 C.t0 VGND.t0 VNB.t5 sky130_fd_pr__nfet_01v8 ad=0.08775 pd=0.92 as=0.08775 ps=0.92 w=0.65 l=0.15 sa=1.1 sb=2.96
X10 a_121_47.t4 B.t1 a_373_47.t5 VNB.t7 sky130_fd_pr__nfet_01v8 ad=0.08775 pd=0.92 as=0.08775 ps=0.92 w=0.65 l=0.15 sa=2.36 sb=1.7
X11 a_373_47.t1 A.t1 Y.t3 VNB.t1 sky130_fd_pr__nfet_01v8 ad=0.08775 pd=0.92 as=0.08775 ps=0.92 w=0.65 l=0.15 sa=3.8 sb=0.26
R0 VGND VGND.n0 0.486586
R1 VGND.n0 VGND.n1 213.924
R2 VGND.n0 VGND.t2 300.901
R3 VGND.n1 VGND.t1 24.9236
R4 VGND.n1 VGND.t0 24.9236
R5 Y.n1 Y.n0 185
R6 Y Y.n1 3.29747
R7 Y.n4 Y.n1 22.121
R8 Y.n5 Y.n4 75.7108
R9 Y Y.n5 1.64144
R10 Y.n5 Y.t0 133.386
R11 Y.n4 Y.n3 28.1445
R12 Y.n3 Y.t5 228.773
R13 Y.n3 Y.n2 317.377
R14 Y.n2 Y.t4 192.076
R15 Y.n2 Y.t2 26.5955
R16 Y.n0 Y.t1 24.9236
R17 Y.n0 Y.t3 24.9236
R18 VPWR VPWR.n0 0.0694753
R19 VPWR.n0 VPWR.n1 617.011
R20 VPWR.n1 VPWR.t0 209.805
R21 VPWR.n1 VPWR.t2 44.3255
R22 VPWR.n0 VPWR.t1 268.503
R23 A A.n0 164.061
R24 A.n0 A.n1 61.346
R25 A.n1 A.t0 201.125
R26 A.n1 A.t1 139.78
R27 A.n0 A.t3 212.081
R28 A.n0 A.t2 139.78
R29 B.n1 B.n0 61.346
R30 B.n2 B.n1 61.346
R31 B B.n2 164.061
R32 B.n2 B.t0 139.78
R33 B.n1 B.t1 139.78
R34 B.n0 B.t3 212.081
R35 B.n0 B.t2 139.78
R36 C C.n0 164.061
R37 C.n0 C.n1 61.346
R38 C.n1 C.t0 201.125
R39 C.n1 C.t1 139.78
R40 C.n0 C.t3 212.081
R41 C.n0 C.t2 139.78
R42 VPB VPB.t1 227.882
R43 VPB.t1 VPB.t2 745.794
R44 VPB.t2 VPB.t0 852.337
R45 VNB VNB.t3 1096.44
R46 VNB.t3 VNB.t4 1196.12
R47 VNB.t4 VNB.t5 1196.12
R48 VNB.t5 VNB.t6 1196.12
R49 VNB.t6 VNB.t7 1196.12
R50 VNB.t7 VNB.t8 1196.12
R51 VNB.t8 VNB.t0 1708.74
R52 VNB.t0 VNB.t1 1196.12
R53 VNB.t1 VNB.t2 1196.12
R54 a_373_47.n0 a_373_47.t1 24.9236
R55 a_373_47.t2 a_373_47.n0 24.9236
R56 a_373_47.n0 a_373_47.n2 261.8
R57 a_373_47.n2 a_373_47.n3 95.684
R58 a_373_47.n3 a_373_47.t4 41.539
R59 a_373_47.n3 a_373_47.t0 41.539
R60 a_373_47.n2 a_373_47.n1 261.8
R61 a_373_47.n1 a_373_47.t3 24.9236
R62 a_373_47.n1 a_373_47.t5 24.9236
R63 a_121_47.n0 a_121_47.n2 98.0123
R64 a_121_47.t2 a_121_47.n0 24.9236
R65 a_121_47.n0 a_121_47.t3 24.9236
R66 a_121_47.n2 a_121_47.n3 275.923
R67 a_121_47.n3 a_121_47.t4 24.9236
R68 a_121_47.n3 a_121_47.t5 24.9236
R69 a_121_47.n2 a_121_47.n1 141.405
R70 a_121_47.n1 a_121_47.t0 24.9236
R71 a_121_47.n1 a_121_47.t1 24.9236
C0 Y VPWR 0.23409f
C1 Y VPB 0.05382f
C2 VGND VPWR 0.05718f
C3 B VPWR 0.01868f
C4 VGND VPB 0.0192f
C5 C VPWR 0.03785f
C6 B VPB 0.07894f
C7 C VPB 0.07627f
C8 VPB VPWR 0.16964f
C9 Y A 0.10422f
C10 VGND A 0.02877f
C11 B A 0.02958f
C12 VGND Y 0.04762f
C13 VPWR A 0.02115f
C14 Y B 0.03203f
C15 VPB A 0.07982f
C16 C Y 0.00298f
C17 VGND B 0.03013f
C18 C VGND 0.05347f
C19 C B 0.02037f
C20 VGND VNB 0.68118f
C21 Y VNB 0f
C22 VPWR VNB 0f
C23 A VNB 0.06639f
C24 B VNB 0.02609f
C25 C VNB 0.10305f
C26 VPB VNB 0.57608f
C27 a_121_47.t2 VNB 0.03067f
C28 a_121_47.n0 VNB 0.02947f
C29 a_121_47.n1 VNB 0.04878f
C30 a_121_47.t0 VNB 0.02588f
C31 a_121_47.t1 VNB 0.02588f
C32 a_121_47.n2 VNB 0.18052f
C33 a_121_47.t4 VNB 0.02887f
C34 a_121_47.t5 VNB 0.02887f
C35 a_121_47.n3 VNB 0.04328f
C36 a_121_47.t3 VNB 0.02887f
C37 a_373_47.t2 VNB 0.03358f
C38 a_373_47.n0 VNB 0.03668f
C39 a_373_47.t3 VNB 0.02843f
C40 a_373_47.t5 VNB 0.02843f
C41 a_373_47.n1 VNB 0.03668f
C42 a_373_47.n2 VNB 0.15332f
C43 a_373_47.n3 VNB 0.0447f
C44 a_373_47.t4 VNB 0.03704f
C45 a_373_47.t0 VNB 0.03646f
C46 a_373_47.t1 VNB 0.02785f
C47 VPB.t0 VNB 0.22252f
C48 VPB.t1 VNB 0.08027f
C49 VPB.t2 VNB 0.13176f
C50 C.n0 VNB 0.05303f
C51 C.n1 VNB 0.06433f
C52 B.n0 VNB 0.05419f
C53 B.n1 VNB 0.05267f
C54 B.n2 VNB 0.05051f
C55 A.n0 VNB 0.06329f
C56 A.n1 VNB 0.07679f
C57 VPWR.n0 VNB 0.34566f
C58 VPWR.t1 VNB 0.04966f
C59 VPWR.t0 VNB 0.08369f
C60 VPWR.t2 VNB 0.03433f
C61 VPWR.n1 VNB 0.0753f
C62 Y.t1 VNB 0.02353f
C63 Y.t3 VNB 0.02353f
C64 Y.n0 VNB 0.01718f
C65 Y.n1 VNB 0.01137f
C66 Y.n2 VNB 0.13912f
C67 Y.t4 VNB 0.11332f
C68 Y.t2 VNB 0.03536f
C69 Y.n3 VNB 0.13748f
C70 Y.t5 VNB 0.06961f
C71 Y.n4 VNB 0.03241f
C72 Y.n5 VNB 0.02813f
C73 Y.t0 VNB 0.04712f
C74 VGND.n0 VNB 0.10212f
C75 VGND.t1 VNB 0.0186f
C76 VGND.t0 VNB 0.0234f
C77 VGND.n1 VNB 0.01402f
C78 VGND.t2 VNB 0.03494f
.ends
