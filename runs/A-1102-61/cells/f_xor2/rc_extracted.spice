* NGSPICE file created from f_xor2.ext - technology: sky130A

.subckt f_xor2 A B VGND VNB VPB VPWR Y
X0 a_133_297# B VPWR VPB sky130_fd_pr__pfet_01v8_hvt ad=0.175 pd=1.35 as=0.26 ps=2.52 w=1 l=0.15 sa=0.26 sb=0.76
X1 VGND a_133_47# Y.t1 VNB sky130_fd_pr__nfet_01v8 ad=0.169 pd=1.82 as=0.08775 ps=0.92 w=0.65 l=0.15 sa=2.765 sb=0.26
X2 VGND A a_133_47# VNB sky130_fd_pr__nfet_01v8 ad=0.25675 pd=1.44 as=0.11375 ps=1 w=0.65 l=0.15 sa=0.76 sb=2.265
X3 a_133_47# B VGND VNB sky130_fd_pr__nfet_01v8 ad=0.11375 pd=1 as=0.169 ps=1.82 w=0.65 l=0.15 sa=0.26 sb=2.765
X4 a_421_47# B VGND VNB sky130_fd_pr__nfet_01v8 ad=0.16087 pd=1.145 as=0.25675 ps=1.44 w=0.65 l=0.15 sa=1.7 sb=1.325
X5 Y.t0 a_133_47# a_339_297# VPB sky130_fd_pr__pfet_01v8_hvt ad=0.26 pd=2.52 as=0.135 ps=1.27 w=1 l=0.15 sa=1.325 sb=0.26
X6 a_133_47# A a_133_297# VPB sky130_fd_pr__pfet_01v8_hvt ad=0.26 pd=2.52 as=0.175 ps=1.35 w=1 l=0.15 sa=0.76 sb=0.26
X7 VPWR B a_339_297# VPB sky130_fd_pr__pfet_01v8_hvt ad=0.2475 pd=1.495 as=0.26 ps=2.52 w=1 l=0.15 sa=0.26 sb=1.325
X8 a_339_297# A VPWR VPB sky130_fd_pr__pfet_01v8_hvt ad=0.135 pd=1.27 as=0.2475 ps=1.495 w=1 l=0.15 sa=0.905 sb=0.68
X9 Y.t2 A a_421_47# VNB sky130_fd_pr__nfet_01v8 ad=0.08775 pd=0.92 as=0.16087 ps=1.145 w=0.65 l=0.15 sa=2.345 sb=0.68
R0 Y Y.t0 331.384
R1 Y.n0 Y 194.892
R2 Y.n1 Y.n0 185
R3 Y.n0 Y.t1 24.9236
R4 Y.n0 Y.t2 24.9236
R5 Y Y.n1 19.1793
R6 Y.n1 Y 3.29747
C0 a_421_47# A 0.01077f
C1 a_133_297# A 0
C2 a_133_47# A 0.11976f
C3 B a_133_297# 0.00455f
C4 VPWR A 0.02826f
C5 B a_133_47# 0.12296f
C6 a_421_47# Y 0.00742f
C7 a_133_297# Y 0
C8 B VPWR 0.0507f
C9 a_133_47# Y 0.08379f
C10 Y VPWR 0.02834f
C11 a_421_47# VGND 0.01542f
C12 VGND a_133_47# 0.09981f
C13 VPB A 0.07091f
C14 VGND VPWR 0.02289f
C15 VPB B 0.07885f
C16 a_339_297# A 0.01306f
C17 VPB Y 0.01789f
C18 a_421_47# a_133_47# 0
C19 a_339_297# B 0.01679f
C20 a_133_47# a_133_297# 0.01944f
C21 a_421_47# VPWR 0.0018f
C22 a_133_297# VPWR 0.01399f
C23 a_339_297# Y 0.02445f
C24 a_133_47# VPWR 0.09147f
C25 VPB VGND 0.00993f
C26 a_339_297# VGND 0.0017f
C27 VPB a_133_47# 0.07131f
C28 VPB VPWR 0.11217f
C29 a_339_297# a_133_47# 0.09234f
C30 a_339_297# VPWR 0.11011f
C31 B A 0.14706f
C32 Y A 0.02511f
C33 B Y 0.00905f
C34 VPB a_339_297# 0.00893f
C35 VGND A 0.08698f
C36 VGND B 0.065f
C37 VGND Y 0.07531f
C38 VGND VNB 0.64322f
C39 Y VNB 0.18558f
C40 VPWR VNB 0.45017f
C41 VPB VNB 0.78196f
C42 a_339_297# VNB 0.04612f
C43 a_133_297# VNB 0.08729f
C44 Y.t0 VNB 0.10304f
C45 Y.t1 VNB 0.09659f
C46 Y.t2 VNB 0.01129f
C47 Y.n0 VNB 0.02349f
C48 Y.n1 VNB 0.05427f
.ends
