* NGSPICE file created from f_nand3.ext - technology: sky130A

.subckt f_nand3 A B C VGND VNB VPB VPWR Y
X0 Y.t0 A.t1 VPWR.t0 VPB.t1 sky130_fd_pr__pfet_01v8_hvt ad=0.26 pd=2.52 as=0.135 ps=1.27 w=1 l=0.15 sa=1.16 sb=0.26
X1 VPWR.t2 B.t1 Y.t3 VPB.t0 sky130_fd_pr__pfet_01v8_hvt ad=0.135 pd=1.27 as=0.165 ps=1.33 w=1 l=0.15 sa=0.74 sb=0.68
X2 a_205_47.t0 B.t0 a_109_47.t0 VNB.t0 sky130_fd_pr__nfet_01v8 ad=0.08775 pd=0.92 as=0.10725 ps=0.98 w=0.65 l=0.15 sa=0.74 sb=0.68
X3 Y.t1 A.t0 a_205_47.t1 VNB.t1 sky130_fd_pr__nfet_01v8 ad=0.169 pd=1.82 as=0.08775 ps=0.92 w=0.65 l=0.15 sa=1.16 sb=0.26
X4 Y.t2 C.t1 VPWR.t1 VPB.t2 sky130_fd_pr__pfet_01v8_hvt ad=0.165 pd=1.33 as=0.26 ps=2.52 w=1 l=0.15 sa=0.26 sb=1.16
X5 a_109_47.t1 C.t0 VGND.t0 VNB.t2 sky130_fd_pr__nfet_01v8 ad=0.10725 pd=0.98 as=0.169 ps=1.82 w=0.65 l=0.15 sa=0.26 sb=1.16
R0 VGND VGND.t0 299.286
R1 Y Y.n0 5.68929
R2 Y.n2 Y.n0 69.2393
R3 Y.n2 Y.t0 222.53
R4 Y.n1 Y.n3 193.627
R5 Y.n1 Y.n2 29.4735
R6 Y Y.n1 7.52007
R7 Y.n3 Y.t2 32.5055
R8 Y.n3 Y.t3 32.5055
R9 Y.n0 Y.t1 129.827
R10 VPWR VPWR.n0 0.358312
R11 VPWR.n0 VPWR.n1 614.097
R12 VPWR.n1 VPWR.t2 26.5955
R13 VPWR.n1 VPWR.t0 26.5955
R14 VPWR.n0 VPWR.t1 266.113
R15 A A.n0 155.298
R16 A.n0 A.t0 158.064
R17 A.n0 A.t1 230.363
R18 B B.n0 155.298
R19 B.n0 B.t0 169.237
R20 B.n0 B.t1 241.536
R21 C C.n0 155.298
R22 C.n0 C.t0 169.237
R23 C.n0 C.t1 241.536
R24 VPB VPB.t2 192.369
R25 VPB.t2 VPB.t0 284.113
R26 VPB.t0 VPB.t1 248.599
R27 VNB VNB.t2 925.567
R28 VNB.t2 VNB.t0 1366.99
R29 VNB.t0 VNB.t1 1196.12
R30 a_205_47.t0 a_205_47.t1 49.8467
R31 a_109_47.t0 a_109_47.t1 60.9236
C0 VGND A 0.00891f
C1 VPWR VGND 0.02528f
C2 B Y 0.04978f
C3 VGND Y 0.05907f
C4 C B 0.03636f
C5 C VGND 0.02274f
C6 A VPB 0.03716f
C7 VPWR VPB 0.05882f
C8 VGND B 0.01804f
C9 Y VPB 0.01743f
C10 VPWR A 0.01407f
C11 VPWR Y 0.14842f
C12 A Y 0.07749f
C13 C VPB 0.0303f
C14 C VPWR 0.03021f
C15 C Y 0.01097f
C16 B VPB 0.02611f
C17 VGND VPB 0.00777f
C18 A B 0.02548f
C19 VPWR B 0.01703f
C20 VGND VNB 0.37971f
C21 Y VNB 0f
C22 VPWR VNB 0.12393f
C23 A VNB 0.06407f
C24 B VNB 0.02055f
C25 C VNB 0.06945f
C26 VPB VNB 0.32957f
C27 a_109_47.t0 VNB 0.0311f
C28 a_109_47.t1 VNB 0.02603f
C29 a_205_47.t0 VNB 0.0273f
C30 a_205_47.t1 VNB 0.02381f
C31 VPB.t0 VNB 0.036f
C32 VPB.t1 VNB 0.0696f
C33 VPB.t2 VNB 0.0322f
C34 C.n0 VNB 0.04254f
C35 B.n0 VNB 0.05666f
C36 A.n0 VNB 0.06561f
C37 VPWR.n0 VNB 0.09098f
C38 VPWR.t1 VNB 0.06153f
C39 VPWR.t2 VNB 0.03814f
C40 VPWR.t0 VNB 0.03335f
C41 VPWR.n1 VNB 0.02061f
C42 Y.n0 VNB 0.05485f
C43 Y.t1 VNB 0.04312f
C44 Y.n1 VNB 0.03667f
C45 Y.n2 VNB 0.10223f
C46 Y.n3 VNB 0.03315f
C47 Y.t2 VNB 0.03755f
C48 Y.t3 VNB 0.04457f
C49 Y.t0 VNB 0.07104f
C50 VGND.t0 VNB 0.033f
.ends
