* NGSPICE file created from a_o22ai_r3.ext - technology: sky130A

.subckt a_o22ai_r3 A B C D VGND VNB VPB VPWR Y
X0 a_55_47# C VGND VNB sky130_fd_pr__nfet_01v8 ad=0.08775 pd=0.92 as=0.11375 ps=1 w=0.65 l=0.15 sa=0.76 sb=1.3
X1 a_321_297# A Y VPB sky130_fd_pr__pfet_01v8_hvt ad=0.235 pd=1.47 as=0.135 ps=1.27 w=1 l=0.15 sa=1.18 sb=0.88
X2 VPWR B a_321_297# VPB sky130_fd_pr__pfet_01v8_hvt ad=0.26 pd=2.52 as=0.235 ps=1.47 w=1 l=0.15 sa=1.8 sb=0.26
X3 VGND D a_55_47# VNB sky130_fd_pr__nfet_01v8 ad=0.11375 pd=1 as=0.169 ps=1.82 w=0.65 l=0.15 sa=0.26 sb=1.8
X4 Y C a_137_297# VPB sky130_fd_pr__pfet_01v8_hvt ad=0.135 pd=1.27 as=0.175 ps=1.35 w=1 l=0.15 sa=0.76 sb=1.3
X5 a_137_297# D VPWR VPB sky130_fd_pr__pfet_01v8_hvt ad=0.175 pd=1.35 as=0.26 ps=2.52 w=1 l=0.15 sa=0.26 sb=1.8
X6 a_55_47# B Y VNB sky130_fd_pr__nfet_01v8 ad=0.169 pd=1.82 as=0.15275 ps=1.12 w=0.65 l=0.15 sa=1.8 sb=0.26
X7 Y A a_55_47# VNB sky130_fd_pr__nfet_01v8 ad=0.15275 pd=1.12 as=0.08775 ps=0.92 w=0.65 l=0.15 sa=1.18 sb=0.88
C0 VGND a_321_297# 0.00294f
C1 VGND D 0.0155f
C2 Y VPB 0.01943f
C3 VPB B 0.03394f
C4 VGND VPB 0.01086f
C5 VPWR a_137_297# 0.02238f
C6 a_321_297# A 0
C7 VPB A 0.02877f
C8 C D 0.03085f
C9 a_55_47# a_137_297# 0.00225f
C10 C VPB 0.02987f
C11 a_55_47# VPWR 0.00715f
C12 D a_137_297# 0
C13 a_321_297# VPWR 0.01898f
C14 VPWR D 0.03204f
C15 VPWR VPB 0.10719f
C16 a_55_47# D 0.02736f
C17 a_55_47# VPB 0.00241f
C18 Y B 0.05528f
C19 VGND Y 0.01682f
C20 VGND B 0.00961f
C21 Y A 0.03336f
C22 A B 0.02776f
C23 VGND A 0.01001f
C24 D VPB 0.0346f
C25 Y C 0.01205f
C26 VGND C 0.01515f
C27 C A 0.03192f
C28 Y a_137_297# 0.00857f
C29 VGND a_137_297# 0.00276f
C30 Y VPWR 0.08097f
C31 VPWR B 0.01736f
C32 VGND VPWR 0.03052f
C33 VPWR A 0.01324f
C34 C a_137_297# 0.00288f
C35 Y a_55_47# 0.06057f
C36 a_55_47# B 0.00698f
C37 VGND a_55_47# 0.16109f
C38 VPWR C 0.01896f
C39 a_55_47# A 0.01765f
C40 a_55_47# C 0.02657f
C41 Y D 0.00434f
C42 Y a_321_297# 0.0246f
C43 a_321_297# B 0
C44 VGND VNB 0.42231f
C45 Y VNB 0.10101f
C46 VPWR VNB 0.36675f
C47 VPB VNB 0.60476f
C48 a_55_47# VNB 0.11959f
C49 a_321_297# VNB 0.07122f
.ends
