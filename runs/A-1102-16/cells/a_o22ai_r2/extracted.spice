* NGSPICE file created from a_o22ai_r2.ext - technology: sky130A

.subckt a_o22ai_r2 A B C D VGND VNB VPB VPWR Y
X0 Y A a_129_297# VPB sky130_fd_pr__pfet_01v8_hvt ad=0.175 pd=1.35 as=0.235 ps=1.47 w=1 l=0.15
X1 VGND C a_47_47# VNB sky130_fd_pr__nfet_01v8 ad=0.11375 pd=1 as=0.11375 ps=1 w=0.65 l=0.15
X2 Y B a_47_47# VNB sky130_fd_pr__nfet_01v8 ad=0.15275 pd=1.12 as=0.169 ps=1.82 w=0.65 l=0.15
X3 a_129_297# B VPWR VPB sky130_fd_pr__pfet_01v8_hvt ad=0.235 pd=1.47 as=0.26 ps=2.52 w=1 l=0.15
X4 a_47_47# A Y VNB sky130_fd_pr__nfet_01v8 ad=0.11375 pd=1 as=0.15275 ps=1.12 w=0.65 l=0.15
X5 VPWR D a_353_297# VPB sky130_fd_pr__pfet_01v8_hvt ad=0.26 pd=2.52 as=0.175 ps=1.35 w=1 l=0.15
X6 a_353_297# C Y VPB sky130_fd_pr__pfet_01v8_hvt ad=0.175 pd=1.35 as=0.175 ps=1.35 w=1 l=0.15
X7 a_47_47# D VGND VNB sky130_fd_pr__nfet_01v8 ad=0.169 pd=1.82 as=0.11375 ps=1 w=0.65 l=0.15
.ends
