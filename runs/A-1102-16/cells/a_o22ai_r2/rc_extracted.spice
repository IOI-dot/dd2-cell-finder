* NGSPICE file created from a_o22ai_r2.ext - technology: sky130A

.subckt a_o22ai_r2 A B C D VGND VNB VPB VPWR Y
X0 Y A a_129_297# VPB sky130_fd_pr__pfet_01v8_hvt ad=0.175 pd=1.35 as=0.235 ps=1.47 w=1 l=0.15 sa=0.88 sb=1.26
X1 VGND C a_47_47# VNB sky130_fd_pr__nfet_01v8 ad=0.11375 pd=1 as=0.11375 ps=1 w=0.65 l=0.15 sa=1.38 sb=0.76
X2 Y B a_47_47# VNB sky130_fd_pr__nfet_01v8 ad=0.15275 pd=1.12 as=0.169 ps=1.82 w=0.65 l=0.15 sa=0.26 sb=1.88
X3 a_129_297# B VPWR VPB sky130_fd_pr__pfet_01v8_hvt ad=0.235 pd=1.47 as=0.26 ps=2.52 w=1 l=0.15 sa=0.26 sb=1.88
X4 a_47_47# A Y VNB sky130_fd_pr__nfet_01v8 ad=0.11375 pd=1 as=0.15275 ps=1.12 w=0.65 l=0.15 sa=0.88 sb=1.26
X5 VPWR D a_353_297# VPB sky130_fd_pr__pfet_01v8_hvt ad=0.26 pd=2.52 as=0.175 ps=1.35 w=1 l=0.15 sa=1.88 sb=0.26
X6 a_353_297# C Y VPB sky130_fd_pr__pfet_01v8_hvt ad=0.175 pd=1.35 as=0.175 ps=1.35 w=1 l=0.15 sa=1.38 sb=0.76
X7 a_47_47# D VGND VNB sky130_fd_pr__nfet_01v8 ad=0.169 pd=1.82 as=0.11375 ps=1 w=0.65 l=0.15 sa=1.88 sb=0.26
C0 Y a_129_297# 0.02435f
C1 VGND a_129_297# 0.00294f
C2 Y VPWR 0.0821f
C3 VPWR D 0.02802f
C4 VGND VPWR 0.0301f
C5 VPWR C 0.02028f
C6 A a_129_297# 0
C7 Y a_47_47# 0.05919f
C8 a_47_47# D 0.02653f
C9 VGND a_47_47# 0.16408f
C10 VPWR A 0.01461f
C11 a_47_47# C 0.02751f
C12 a_47_47# A 0.01713f
C13 Y B 0.05511f
C14 Y a_353_297# 0.00834f
C15 a_353_297# D 0.00288f
C16 VGND a_353_297# 0.00276f
C17 VGND B 0.00953f
C18 Y VPB 0.01934f
C19 VPB D 0.03481f
C20 VGND VPB 0.00954f
C21 VPWR a_129_297# 0.01893f
C22 a_353_297# C 0
C23 VPB C 0.0301f
C24 A B 0.02776f
C25 A VPB 0.02993f
C26 a_47_47# VPWR 0.00945f
C27 B a_129_297# 0
C28 a_353_297# VPWR 0.02237f
C29 VPWR B 0.0173f
C30 VPWR VPB 0.10413f
C31 a_47_47# B 0.00692f
C32 a_47_47# a_353_297# 0.00225f
C33 a_47_47# VPB 0.00267f
C34 Y D 0.00405f
C35 VGND Y 0.01705f
C36 VGND D 0.0156f
C37 Y C 0.01445f
C38 C D 0.03085f
C39 VGND C 0.0165f
C40 B VPB 0.03365f
C41 Y A 0.03351f
C42 VGND A 0.01038f
C43 A C 0.03085f
C44 VGND VNB 0.37592f
C45 Y VNB 0.14346f
C46 VPWR VNB 0.37075f
C47 VPB VNB 0.60476f
C48 a_47_47# VNB 0.11795f
C49 a_353_297# VNB 0.04494f
C50 a_129_297# VNB 0.02906f
.ends
