* NGSPICE file created from a_o22ai_r1.ext - technology: sky130A

.subckt a_o22ai_r1 A B C D VGND VNB VPB VPWR Y
X0 a_241_297# B VPWR VPB sky130_fd_pr__pfet_01v8_hvt ad=0.175 pd=1.35 as=0.175 ps=1.35 w=1 l=0.15 sa=0.76 sb=1.26
X1 a_141_47# A Y VNB sky130_fd_pr__nfet_01v8 ad=0.11375 pd=1 as=0.11375 ps=1 w=0.65 l=0.15 sa=1.26 sb=0.76
X2 VPWR D a_59_297# VPB sky130_fd_pr__pfet_01v8_hvt ad=0.175 pd=1.35 as=0.26 ps=2.52 w=1 l=0.15 sa=0.26 sb=1.76
X3 Y B a_141_47# VNB sky130_fd_pr__nfet_01v8 ad=0.11375 pd=1 as=0.11375 ps=1 w=0.65 l=0.15 sa=0.76 sb=1.26
X4 a_59_297# C Y VPB sky130_fd_pr__pfet_01v8_hvt ad=0.26 pd=2.52 as=0.175 ps=1.35 w=1 l=0.15 sa=1.76 sb=0.26
X5 a_141_47# D VGND VNB sky130_fd_pr__nfet_01v8 ad=0.11375 pd=1 as=0.169 ps=1.82 w=0.65 l=0.15 sa=0.26 sb=1.76
X6 Y A a_241_297# VPB sky130_fd_pr__pfet_01v8_hvt ad=0.175 pd=1.35 as=0.175 ps=1.35 w=1 l=0.15 sa=1.26 sb=0.76
X7 VGND C a_141_47# VNB sky130_fd_pr__nfet_01v8 ad=0.169 pd=1.82 as=0.11375 ps=1 w=0.65 l=0.15 sa=1.76 sb=0.26
C0 Y VPWR 0.01604f
C1 a_59_297# A 0.01935f
C2 VPWR C 0.01028f
C3 VGND VPWR 0.03044f
C4 VPWR A 0.01099f
C5 B a_59_297# 0.02164f
C6 Y a_141_47# 0.04973f
C7 a_141_47# C 0.00212f
C8 VGND a_141_47# 0.11569f
C9 VPWR B 0.01726f
C10 a_141_47# A 0.0075f
C11 a_141_47# B 0.02061f
C12 Y D 0.00106f
C13 Y a_241_297# 0.00308f
C14 VGND a_241_297# 0.00193f
C15 VGND D 0.02981f
C16 Y VPB 0.0161f
C17 VPB C 0.03259f
C18 VGND VPB 0.01167f
C19 VPWR a_59_297# 0.139f
C20 a_241_297# A 0.0014f
C21 VPB A 0.02969f
C22 a_241_297# B 0
C23 B D 0.03085f
C24 a_141_47# a_59_297# 0.00205f
C25 B VPB 0.02921f
C26 a_141_47# VPWR 0.00352f
C27 a_241_297# a_59_297# 0.0179f
C28 D a_59_297# 0.027f
C29 VPB a_59_297# 0.02248f
C30 VPWR D 0.01514f
C31 a_241_297# VPWR 0.00916f
C32 VPWR VPB 0.0821f
C33 a_141_47# D 0.00543f
C34 a_141_47# VPB 0.00102f
C35 Y C 0.0559f
C36 VGND Y 0.03575f
C37 VGND C 0.01672f
C38 Y A 0.02624f
C39 A C 0.03085f
C40 VGND A 0.0105f
C41 D VPB 0.03285f
C42 Y B 0.00459f
C43 VGND B 0.01112f
C44 B A 0.03085f
C45 Y a_59_297# 0.04241f
C46 a_59_297# C 0.01115f
C47 VGND a_59_297# 0.00708f
C48 VGND VNB 0.39219f
C49 Y VNB 0.13393f
C50 VPWR VNB 0.35846f
C51 VPB VNB 0.60476f
C52 a_141_47# VNB 0.03538f
C53 a_241_297# VNB 0.02845f
C54 a_59_297# VNB 0.13513f
.ends
