* NGSPICE file created from a_nor2_r2.ext - technology: sky130A

.subckt a_nor2_r2 A B VGND VNB VPB VPWR Y
X0 a_111_297# B VPWR VPB sky130_fd_pr__pfet_01v8_hvt ad=0.135 pd=1.27 as=0.26 ps=2.52 w=1 l=0.15 sa=0.26 sb=0.68
X1 VGND A Y VNB sky130_fd_pr__nfet_01v8 ad=0.169 pd=1.82 as=0.08775 ps=0.92 w=0.65 l=0.15 sa=0.68 sb=0.26
X2 Y B VGND VNB sky130_fd_pr__nfet_01v8 ad=0.08775 pd=0.92 as=0.169 ps=1.82 w=0.65 l=0.15 sa=0.26 sb=0.68
X3 Y A a_111_297# VPB sky130_fd_pr__pfet_01v8_hvt ad=0.26 pd=2.52 as=0.135 ps=1.27 w=1 l=0.15 sa=0.68 sb=0.26
C0 A VPB 0.03824f
C1 VGND B 0.0354f
C2 VPWR VPB 0.04959f
C3 Y VPB 0.0151f
C4 VPWR A 0.00887f
C5 Y A 0.05773f
C6 VPWR a_111_297# 0.00528f
C7 Y a_111_297# 0.01381f
C8 VGND VPB 0.00503f
C9 Y VPWR 0.08811f
C10 VGND A 0.03393f
C11 B VPB 0.03893f
C12 VGND a_111_297# 0
C13 VGND VPWR 0.0171f
C14 A B 0.02548f
C15 Y VGND 0.08161f
C16 VPWR B 0.03756f
C17 Y B 0.03188f
C18 VGND VNB 0.31287f
C19 Y VNB 0.11819f
C20 VPWR VNB 0.25886f
C21 VPB VNB 0.33898f
C22 a_111_297# VNB 0.05367f
.ends
