* NGSPICE file created from a_o21ai_r1.ext - technology: sky130A

.subckt a_o21ai_r1 A B C VGND VNB VPB VPWR Y
X0 Y C VPWR VPB sky130_fd_pr__pfet_01v8_hvt ad=0.175 pd=1.35 as=0.26 ps=2.52 w=1 l=0.15 sa=0.26 sb=1.26
X1 VGND A a_145_47# VNB sky130_fd_pr__nfet_01v8 ad=0.11375 pd=1 as=0.11375 ps=1 w=0.65 l=0.15 sa=0.76 sb=0.76
X2 VPWR B a_245_297# VPB sky130_fd_pr__pfet_01v8_hvt ad=0.26 pd=2.52 as=0.175 ps=1.35 w=1 l=0.15 sa=1.26 sb=0.26
X3 a_145_47# C Y VNB sky130_fd_pr__nfet_01v8 ad=0.11375 pd=1 as=0.169 ps=1.82 w=0.65 l=0.15 sa=0.26 sb=1.26
X4 a_245_297# A Y VPB sky130_fd_pr__pfet_01v8_hvt ad=0.175 pd=1.35 as=0.175 ps=1.35 w=1 l=0.15 sa=0.76 sb=0.76
X5 a_145_47# B VGND VNB sky130_fd_pr__nfet_01v8 ad=0.169 pd=1.82 as=0.11375 ps=1 w=0.65 l=0.15 sa=1.26 sb=0.26
C0 A B 0.03085f
C1 a_145_47# VPB 0.0024f
C2 Y a_245_297# 0.00849f
C3 VGND a_245_297# 0.00276f
C4 A VPB 0.0301f
C5 VPB C 0.03342f
C6 VGND Y 0.04506f
C7 VPWR a_245_297# 0.02253f
C8 VPB B 0.03536f
C9 a_145_47# a_245_297# 0.00225f
C10 Y VPWR 0.09155f
C11 VGND VPWR 0.02637f
C12 a_145_47# Y 0.02486f
C13 a_145_47# VGND 0.09551f
C14 A a_245_297# 0
C15 A Y 0.01531f
C16 B a_245_297# 0.00288f
C17 A VGND 0.0165f
C18 a_145_47# VPWR 0.00844f
C19 Y C 0.05245f
C20 VGND C 0.01538f
C21 Y B 0.00439f
C22 VGND B 0.01568f
C23 A VPWR 0.02075f
C24 VPWR C 0.01825f
C25 a_145_47# A 0.02707f
C26 Y VPB 0.02194f
C27 a_145_47# C 0.00499f
C28 VPWR B 0.02828f
C29 VGND VPB 0.01013f
C30 a_145_47# B 0.02645f
C31 A C 0.03085f
C32 VPWR VPB 0.09544f
C33 VGND VNB 0.33027f
C34 Y VNB 0.13645f
C35 VPWR VNB 0.37353f
C36 VPB VNB 0.51617f
C37 a_145_47# VNB 0.06179f
C38 a_245_297# VNB 0.04467f
.ends
