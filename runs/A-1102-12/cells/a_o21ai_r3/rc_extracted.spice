* NGSPICE file created from a_o21ai_r3.ext - technology: sky130A

.subckt a_o21ai_r3 A B C VGND VNB VPB VPWR Y
X0 VPWR C Y VPB sky130_fd_pr__pfet_01v8_hvt ad=0.175 pd=1.35 as=0.26 ps=2.52 w=1 l=0.15 sa=0.26 sb=1.26
X1 VGND B a_145_47# VNB sky130_fd_pr__nfet_01v8 ad=0.11375 pd=1 as=0.11375 ps=1 w=0.65 l=0.15 sa=0.76 sb=0.76
X2 Y A a_245_297# VPB sky130_fd_pr__pfet_01v8_hvt ad=0.26 pd=2.52 as=0.175 ps=1.35 w=1 l=0.15 sa=1.26 sb=0.26
X3 a_145_47# C Y VNB sky130_fd_pr__nfet_01v8 ad=0.11375 pd=1 as=0.169 ps=1.82 w=0.65 l=0.15 sa=0.26 sb=1.26
X4 a_245_297# B VPWR VPB sky130_fd_pr__pfet_01v8_hvt ad=0.175 pd=1.35 as=0.175 ps=1.35 w=1 l=0.15 sa=0.76 sb=0.76
X5 a_145_47# A VGND VNB sky130_fd_pr__nfet_01v8 ad=0.169 pd=1.82 as=0.11375 ps=1 w=0.65 l=0.15 sa=1.26 sb=0.26
C0 a_145_47# A 0.02645f
C1 B C 0.03085f
C2 Y VPB 0.03729f
C3 B A 0.03085f
C4 a_145_47# VPB 0.0018f
C5 VPWR a_245_297# 0.01192f
C6 VGND a_245_297# 0.00228f
C7 B VPB 0.02921f
C8 VPB C 0.03298f
C9 VGND VPWR 0.02547f
C10 VPB A 0.03348f
C11 Y a_245_297# 0.02144f
C12 a_145_47# a_245_297# 0.00107f
C13 VPWR Y 0.13749f
C14 VGND Y 0.04748f
C15 a_145_47# VPWR 0.0035f
C16 a_145_47# VGND 0.09551f
C17 B a_245_297# 0
C18 B VPWR 0.0172f
C19 A a_245_297# 0.00135f
C20 B VGND 0.0163f
C21 a_145_47# Y 0.03063f
C22 VPWR C 0.01506f
C23 VGND C 0.01522f
C24 VPWR A 0.01232f
C25 VGND A 0.01531f
C26 B Y 0.02382f
C27 Y C 0.05453f
C28 a_145_47# B 0.02707f
C29 VPWR VPB 0.06921f
C30 a_145_47# C 0.00499f
C31 Y A 0.02536f
C32 VGND VPB 0.00915f
C33 VGND VNB 0.33027f
C34 VPWR VNB 0.28956f
C35 Y VNB 0.22329f
C36 VPB VNB 0.51617f
C37 a_145_47# VNB 0.06179f
C38 a_245_297# VNB 0.04467f
.ends
