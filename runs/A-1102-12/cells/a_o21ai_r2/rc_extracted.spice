* NGSPICE file created from a_o21ai_r2.ext - technology: sky130A

.subckt a_o21ai_r2 A B C VGND VNB VPB VPWR Y
X0 a_145_297# A Y VPB sky130_fd_pr__pfet_01v8_hvt ad=0.175 pd=1.35 as=0.26 ps=2.52 w=1 l=0.15 sa=0.26 sb=1.26
X1 a_63_47# B VGND VNB sky130_fd_pr__nfet_01v8 ad=0.11375 pd=1 as=0.11375 ps=1 w=0.65 l=0.15 sa=0.76 sb=0.76
X2 Y C VPWR VPB sky130_fd_pr__pfet_01v8_hvt ad=0.26 pd=2.52 as=0.175 ps=1.35 w=1 l=0.15 sa=1.26 sb=0.26
X3 VGND A a_63_47# VNB sky130_fd_pr__nfet_01v8 ad=0.11375 pd=1 as=0.169 ps=1.82 w=0.65 l=0.15 sa=0.26 sb=1.26
X4 VPWR B a_145_297# VPB sky130_fd_pr__pfet_01v8_hvt ad=0.175 pd=1.35 as=0.175 ps=1.35 w=1 l=0.15 sa=0.76 sb=0.76
X5 Y C a_63_47# VNB sky130_fd_pr__nfet_01v8 ad=0.169 pd=1.82 as=0.11375 ps=1 w=0.65 l=0.15 sa=1.26 sb=0.26
C0 a_63_47# VGND 0.10095f
C1 B a_145_297# 0.00135f
C2 A a_145_297# 0
C3 B VPWR 0.01606f
C4 B VGND 0.01643f
C5 a_63_47# Y 0.02713f
C6 VPWR A 0.01232f
C7 VGND A 0.01518f
C8 VPWR C 0.01631f
C9 VGND C 0.01695f
C10 B Y 0.02418f
C11 Y A 0.0281f
C12 a_63_47# B 0.02675f
C13 VPWR VPB 0.07247f
C14 a_63_47# A 0.02731f
C15 Y C 0.04407f
C16 VGND VPB 0.01091f
C17 a_63_47# C 0.01154f
C18 B A 0.03085f
C19 Y VPB 0.03418f
C20 B C 0.03085f
C21 a_63_47# VPB 0.0017f
C22 VPWR a_145_297# 0.01192f
C23 VGND a_145_297# 0.00228f
C24 B VPB 0.02921f
C25 VPB A 0.03298f
C26 VGND VPWR 0.02594f
C27 Y a_145_297# 0.0215f
C28 VPB C 0.03348f
C29 a_63_47# a_145_297# 0.00107f
C30 VPWR Y 0.12749f
C31 VGND Y 0.03115f
C32 a_63_47# VPWR 0.00371f
C33 VGND VNB 0.33302f
C34 VPWR VNB 0.29084f
C35 Y VNB 0.21743f
C36 VPB VNB 0.51617f
C37 a_63_47# VNB 0.06057f
C38 a_145_297# VNB 0.0447f
.ends
