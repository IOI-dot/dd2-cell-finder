* NGSPICE file created from f_o21ai.ext - technology: sky130A

.subckt f_o21ai A B C VGND VNB VPB VPWR Y
X0 a_145_297.t1 B.t1 VPWR.t1 VPB.t2 sky130_fd_pr__pfet_01v8_hvt ad=0.175 pd=1.35 as=0.26 ps=2.52 w=1 l=0.15 sa=0.26 sb=1.26
X1 a_63_47.t0 A.t0 VGND.t0 VNB.t0 sky130_fd_pr__nfet_01v8 ad=0.11375 pd=1 as=0.11375 ps=1 w=0.65 l=0.15 sa=0.76 sb=0.76
X2 VPWR.t0 C.t1 Y.t2 VPB.t1 sky130_fd_pr__pfet_01v8_hvt ad=0.26 pd=2.52 as=0.175 ps=1.35 w=1 l=0.15 sa=1.26 sb=0.26
X3 VGND.t1 B.t0 a_63_47.t2 VNB.t2 sky130_fd_pr__nfet_01v8 ad=0.11375 pd=1 as=0.169 ps=1.82 w=0.65 l=0.15 sa=0.26 sb=1.26
X4 Y.t0 A.t1 a_145_297.t0 VPB.t0 sky130_fd_pr__pfet_01v8_hvt ad=0.175 pd=1.35 as=0.175 ps=1.35 w=1 l=0.15 sa=0.76 sb=0.76
X5 Y.t1 C.t0 a_63_47.t1 VNB.t1 sky130_fd_pr__nfet_01v8 ad=0.169 pd=1.82 as=0.11375 ps=1 w=0.65 l=0.15 sa=1.26 sb=0.26
R0 VGND VGND.n0 219.802
R1 VGND.n0 VGND.t1 32.3082
R2 VGND.n0 VGND.t0 32.3082
R3 Y Y.n3 6.8005
R4 Y Y.n3 3.2005
R5 Y.n3 Y.n0 0.2005
R6 Y.n1 Y.n2 294.228
R7 Y.n0 Y.n1 135.786
R8 Y.n1 Y 11.4261
R9 Y Y.n2 588.298
R10 Y.n2 Y.t0 34.4755
R11 Y.n2 Y.t2 34.4755
R12 Y.n0 Y.t1 249.615
R13 VPWR VPWR.n0 0.163111
R14 VPWR.n0 VPWR.t0 889.303
R15 VPWR.n0 VPWR.t1 270.245
R16 C C.n0 158.4
R17 C.n0 C.t0 169.237
R18 C.n0 C.t1 241.536
R19 A A.n0 158.4
R20 A.n0 A.t0 169.237
R21 A.n0 A.t1 241.536
R22 B B.n0 158.4
R23 B.n0 B.t0 169.237
R24 B.n0 B.t1 241.536
R25 VPB VPB.t2 298.911
R26 VPB.t2 VPB.t0 295.95
R27 VPB.t0 VPB.t1 295.95
R28 VNB VNB.t2 1438.19
R29 VNB.t2 VNB.t0 1423.95
R30 VNB.t0 VNB.t1 1423.95
R31 a_63_47.n0 a_63_47.t2 295.553
R32 a_63_47.t0 a_63_47.n0 32.3082
R33 a_63_47.n0 a_63_47.t1 32.3082
R34 a_145_297.t0 a_145_297.t1 68.9505
C0 VPWR VGND 0.02685f
C1 A VPB 0.03106f
C2 B VPB 0.03487f
C3 B Y 0.00446f
C4 A Y 0.01048f
C5 A VPWR 0.02192f
C6 VPWR B 0.03224f
C7 VPB C 0.03321f
C8 Y C 0.04758f
C9 VPWR C 0.01713f
C10 B VGND 0.01554f
C11 A VGND 0.01664f
C12 VGND C 0.01711f
C13 VPB Y 0.01825f
C14 VPWR VPB 0.09691f
C15 A B 0.03085f
C16 VPWR Y 0.08793f
C17 VPB VGND 0.01146f
C18 A C 0.03085f
C19 VGND Y 0.02906f
C20 VGND VNB 0.43393f
C21 Y VNB 0f
C22 VPWR VNB 0.10334f
C23 C VNB 0.05197f
C24 A VNB 0.02138f
C25 B VNB 0.05927f
C26 VPB VNB 0.38815f
C27 a_145_297.t0 VNB 0.0475f
C28 a_145_297.t1 VNB 0.04336f
C29 a_63_47.t0 VNB 0.03321f
C30 a_63_47.n0 VNB 0.09186f
C31 a_63_47.t2 VNB 0.09964f
C32 a_63_47.t1 VNB 0.03157f
C33 VPB.t0 VNB 0.04253f
C34 VPB.t1 VNB 0.09272f
C35 VPB.t2 VNB 0.04274f
C36 B.n0 VNB 0.04767f
C37 A.n0 VNB 0.05603f
C38 C.n0 VNB 0.05145f
C39 VPWR.n0 VNB 0.15335f
C40 VPWR.t1 VNB 0.06128f
C41 VPWR.t0 VNB 0.05797f
C42 Y.t1 VNB 0.0479f
C43 Y.n0 VNB 0.04145f
C44 Y.n1 VNB 0.06481f
C45 Y.n2 VNB 0.03427f
C46 Y.t0 VNB 0.04472f
C47 Y.t2 VNB 0.04246f
C48 Y.n3 VNB 0.0066f
C49 VGND.t1 VNB 0.02401f
C50 VGND.t0 VNB 0.027f
C51 VGND.n0 VNB 0.01584f
.ends
