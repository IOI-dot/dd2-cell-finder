* NGSPICE file created from a_a21oi_r1.ext - technology: sky130A

.subckt a_a21oi_r1 A B C VGND VNB VPB VPWR Y
X0 a_109_297# B VPWR VPB sky130_fd_pr__pfet_01v8_hvt ad=0.26 pd=2.52 as=0.135 ps=1.27 w=1 l=0.15 sa=1.16 sb=0.26
X1 VPWR A a_109_297# VPB sky130_fd_pr__pfet_01v8_hvt ad=0.135 pd=1.27 as=0.165 ps=1.33 w=1 l=0.15 sa=0.74 sb=0.68
X2 a_205_47# A Y VNB sky130_fd_pr__nfet_01v8 ad=0.08775 pd=0.92 as=0.10725 ps=0.98 w=0.65 l=0.15 sa=0.74 sb=0.68
X3 VGND B a_205_47# VNB sky130_fd_pr__nfet_01v8 ad=0.169 pd=1.82 as=0.08775 ps=0.92 w=0.65 l=0.15 sa=1.16 sb=0.26
X4 a_109_297# C Y VPB sky130_fd_pr__pfet_01v8_hvt ad=0.165 pd=1.33 as=0.26 ps=2.52 w=1 l=0.15 sa=0.26 sb=1.16
X5 Y C VGND VNB sky130_fd_pr__nfet_01v8 ad=0.10725 pd=0.98 as=0.169 ps=1.82 w=0.65 l=0.15 sa=0.26 sb=1.16
C0 VGND C 0.02242f
C1 VPWR B 0.01542f
C2 VGND B 0.02566f
C3 VPB a_109_297# 0.00963f
C4 A Y 0.05663f
C5 Y C 0.03291f
C6 VPWR VPB 0.04793f
C7 Y B 0.03067f
C8 VGND VPB 0.00638f
C9 A C 0.03636f
C10 Y VPB 0.01791f
C11 A B 0.02548f
C12 VPWR a_109_297# 0.09549f
C13 VGND a_109_297# 0.00681f
C14 A VPB 0.0261f
C15 VPB C 0.0302f
C16 VGND VPWR 0.02047f
C17 Y a_109_297# 0.06197f
C18 VPB B 0.03716f
C19 VPWR Y 0.04079f
C20 VGND Y 0.08854f
C21 a_205_47# VPWR 0
C22 a_205_47# VGND 0.00238f
C23 A a_109_297# 0.01344f
C24 C a_109_297# 0.00445f
C25 A VPWR 0.01537f
C26 B a_109_297# 0.02391f
C27 A VGND 0.0107f
C28 a_205_47# Y 0.01163f
C29 VPWR C 0.01232f
C30 VGND VNB 0.28134f
C31 VPWR VNB 0.29409f
C32 Y VNB 0.13866f
C33 VPB VNB 0.42757f
C34 a_109_297# VNB 0.15443f
.ends
