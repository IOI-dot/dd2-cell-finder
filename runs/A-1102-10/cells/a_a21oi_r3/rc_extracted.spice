* NGSPICE file created from a_a21oi_r3.ext - technology: sky130A

.subckt a_a21oi_r3 A B C VGND VNB VPB VPWR Y
X0 a_145_297# C Y VPB sky130_fd_pr__pfet_01v8_hvt ad=0.175 pd=1.35 as=0.26 ps=2.52 w=1 l=0.15 sa=0.26 sb=1.26
X1 a_245_47# B VGND VNB sky130_fd_pr__nfet_01v8 ad=0.11375 pd=1 as=0.11375 ps=1 w=0.65 l=0.15 sa=0.76 sb=0.76
X2 a_145_297# A VPWR VPB sky130_fd_pr__pfet_01v8_hvt ad=0.26 pd=2.52 as=0.175 ps=1.35 w=1 l=0.15 sa=1.26 sb=0.26
X3 VGND C Y VNB sky130_fd_pr__nfet_01v8 ad=0.11375 pd=1 as=0.169 ps=1.82 w=0.65 l=0.15 sa=0.26 sb=1.26
X4 VPWR B a_145_297# VPB sky130_fd_pr__pfet_01v8_hvt ad=0.175 pd=1.35 as=0.175 ps=1.35 w=1 l=0.15 sa=0.76 sb=0.76
X5 Y A a_245_47# VNB sky130_fd_pr__nfet_01v8 ad=0.169 pd=1.82 as=0.11375 ps=1 w=0.65 l=0.15 sa=1.26 sb=0.26
C0 B VPB 0.02917f
C1 VPB C 0.03373f
C2 VGND VPWR 0.02531f
C3 Y a_145_297# 0.04583f
C4 VPB A 0.03348f
C5 VPWR Y 0.04922f
C6 VGND Y 0.11574f
C7 a_245_47# VPWR 0.0011f
C8 a_245_47# VGND 0.01019f
C9 B a_145_297# 0.02869f
C10 C a_145_297# 0.00792f
C11 B VPWR 0.01606f
C12 A a_145_297# 0.02561f
C13 B VGND 0.01643f
C14 a_245_47# Y 0.01327f
C15 VPWR C 0.01456f
C16 VGND C 0.01534f
C17 VPWR A 0.01602f
C18 VGND A 0.01289f
C19 VPB a_145_297# 0.0219f
C20 B Y 0.02623f
C21 Y C 0.05687f
C22 VPWR VPB 0.06945f
C23 Y A 0.02686f
C24 VGND VPB 0.00894f
C25 B C 0.03085f
C26 Y VPB 0.02398f
C27 B A 0.03085f
C28 VPWR a_145_297# 0.10979f
C29 VGND a_145_297# 0.00477f
C30 VGND VNB 0.33314f
C31 VPWR VNB 0.29215f
C32 Y VNB 0.17645f
C33 VPB VNB 0.51617f
C34 a_245_47# VNB 0.02845f
C35 a_145_297# VNB 0.12069f
.ends
