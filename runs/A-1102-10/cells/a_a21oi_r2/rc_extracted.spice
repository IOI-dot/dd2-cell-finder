* NGSPICE file created from a_a21oi_r2.ext - technology: sky130A

.subckt a_a21oi_r2 A B C VGND VNB VPB VPWR Y
X0 VPWR A a_63_297# VPB sky130_fd_pr__pfet_01v8_hvt ad=0.175 pd=1.35 as=0.26 ps=2.52 w=1 l=0.15 sa=0.26 sb=1.26
X1 VGND B a_145_47# VNB sky130_fd_pr__nfet_01v8 ad=0.11375 pd=1 as=0.11375 ps=1 w=0.65 l=0.15 sa=0.76 sb=0.76
X2 Y C a_63_297# VPB sky130_fd_pr__pfet_01v8_hvt ad=0.26 pd=2.52 as=0.175 ps=1.35 w=1 l=0.15 sa=1.26 sb=0.26
X3 a_145_47# A Y VNB sky130_fd_pr__nfet_01v8 ad=0.11375 pd=1 as=0.169 ps=1.82 w=0.65 l=0.15 sa=0.26 sb=1.26
X4 a_63_297# B VPWR VPB sky130_fd_pr__pfet_01v8_hvt ad=0.175 pd=1.35 as=0.175 ps=1.35 w=1 l=0.15 sa=0.76 sb=0.76
X5 Y C VGND VNB sky130_fd_pr__nfet_01v8 ad=0.169 pd=1.82 as=0.11375 ps=1 w=0.65 l=0.15 sa=1.26 sb=0.26
C0 B A 0.03085f
C1 VPWR VPB 0.07231f
C2 B C 0.03085f
C3 Y a_63_297# 0.03969f
C4 VGND a_63_297# 0.00446f
C5 B VPB 0.02921f
C6 VPB A 0.03298f
C7 VGND Y 0.1121f
C8 VPWR a_63_297# 0.11452f
C9 VPB C 0.03437f
C10 Y VPWR 0.03334f
C11 VGND VPWR 0.02594f
C12 a_145_47# Y 0.01327f
C13 a_145_47# VGND 0.01019f
C14 B a_63_297# 0.02555f
C15 A a_63_297# 0.02805f
C16 B Y 0.02688f
C17 C a_63_297# 0.01365f
C18 B VGND 0.0163f
C19 a_145_47# VPWR 0.0011f
C20 Y A 0.02786f
C21 VGND A 0.01289f
C22 Y C 0.04823f
C23 VGND C 0.01568f
C24 VPB a_63_297# 0.01517f
C25 B VPWR 0.0172f
C26 VPWR A 0.01487f
C27 Y VPB 0.02234f
C28 VPWR C 0.01646f
C29 VGND VPB 0.01095f
C30 VGND VNB 0.33425f
C31 Y VNB 0.1734f
C32 VPWR VNB 0.29316f
C33 VPB VNB 0.51617f
C34 a_145_47# VNB 0.02845f
C35 a_63_297# VNB 0.11701f
.ends
