* NGSPICE file created from a_maj3_r1.ext - technology: sky130A

.subckt a_maj3_r1 A B C VGND VNB VPB VPWR Y
X0 a_235_297# B VPWR VPB sky130_fd_pr__pfet_01v8_hvt ad=0.3175 pd=1.635 as=0.135 ps=1.27 w=1 l=0.15
X1 VPWR C a_392_297# VPB sky130_fd_pr__pfet_01v8_hvt ad=0.26 pd=2.52 as=0.2475 ps=1.495 w=1 l=0.15
X2 a_235_47# B VGND VNB sky130_fd_pr__nfet_01v8 ad=0.20638 pd=1.285 as=0.08775 ps=0.92 w=0.65 l=0.15
X3 VPWR a_97_199# Y VPB sky130_fd_pr__pfet_01v8_hvt ad=0.135 pd=1.27 as=0.26 ps=2.52 w=1 l=0.15
X4 a_235_47# C a_97_199# VNB sky130_fd_pr__nfet_01v8 ad=0.169 pd=1.82 as=0.16087 ps=1.145 w=0.65 l=0.15
X5 a_392_297# A a_97_199# VPB sky130_fd_pr__pfet_01v8_hvt ad=0.2475 pd=1.495 as=0.135 ps=1.27 w=1 l=0.15
X6 a_97_199# B a_392_297# VPB sky130_fd_pr__pfet_01v8_hvt ad=0.135 pd=1.27 as=0.175 ps=1.35 w=1 l=0.15
X7 a_392_297# A a_235_297# VPB sky130_fd_pr__pfet_01v8_hvt ad=0.175 pd=1.35 as=0.3175 ps=1.635 w=1 l=0.15
X8 a_492_47# B VGND VNB sky130_fd_pr__nfet_01v8 ad=0.08775 pd=0.92 as=0.11375 ps=1 w=0.65 l=0.15
X9 VGND a_97_199# Y VNB sky130_fd_pr__nfet_01v8 ad=0.08775 pd=0.92 as=0.169 ps=1.82 w=0.65 l=0.15
X10 VGND A a_235_47# VNB sky130_fd_pr__nfet_01v8 ad=0.11375 pd=1 as=0.20638 ps=1.285 w=0.65 l=0.15
X11 a_97_199# A a_492_47# VNB sky130_fd_pr__nfet_01v8 ad=0.16087 pd=1.145 as=0.08775 ps=0.92 w=0.65 l=0.15
.ends
