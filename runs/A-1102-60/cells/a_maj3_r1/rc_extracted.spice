* NGSPICE file created from a_maj3_r1.ext - technology: sky130A

.subckt a_maj3_r1 A B C VGND VNB VPB VPWR Y
X0 a_235_297# B VPWR VPB sky130_fd_pr__pfet_01v8_hvt ad=0.3175 pd=1.635 as=0.135 ps=1.27 w=1 l=0.15 sa=0.68 sb=2.61
X1 VPWR C a_392_297# VPB sky130_fd_pr__pfet_01v8_hvt ad=0.26 pd=2.52 as=0.2475 ps=1.495 w=1 l=0.15 sa=3.03 sb=0.26
X2 a_235_47# B VGND VNB sky130_fd_pr__nfet_01v8 ad=0.20638 pd=1.285 as=0.08775 ps=0.92 w=0.65 l=0.15 sa=0.68 sb=2.61
X3 VPWR a_97_199# Y VPB sky130_fd_pr__pfet_01v8_hvt ad=0.135 pd=1.27 as=0.26 ps=2.52 w=1 l=0.15 sa=0.26 sb=3.03
X4 a_235_47# C a_97_199# VNB sky130_fd_pr__nfet_01v8 ad=0.169 pd=1.82 as=0.16087 ps=1.145 w=0.65 l=0.15 sa=3.03 sb=0.26
X5 a_392_297# A a_97_199# VPB sky130_fd_pr__pfet_01v8_hvt ad=0.2475 pd=1.495 as=0.135 ps=1.27 w=1 l=0.15 sa=2.385 sb=0.905
X6 a_97_199# B a_392_297# VPB sky130_fd_pr__pfet_01v8_hvt ad=0.135 pd=1.27 as=0.175 ps=1.35 w=1 l=0.15 sa=1.965 sb=1.325
X7 a_392_297# A a_235_297# VPB sky130_fd_pr__pfet_01v8_hvt ad=0.175 pd=1.35 as=0.3175 ps=1.635 w=1 l=0.15 sa=1.465 sb=1.825
X8 a_492_47# B VGND VNB sky130_fd_pr__nfet_01v8 ad=0.08775 pd=0.92 as=0.11375 ps=1 w=0.65 l=0.15 sa=1.965 sb=1.325
X9 VGND a_97_199# Y VNB sky130_fd_pr__nfet_01v8 ad=0.08775 pd=0.92 as=0.169 ps=1.82 w=0.65 l=0.15 sa=0.26 sb=3.03
X10 VGND A a_235_47# VNB sky130_fd_pr__nfet_01v8 ad=0.11375 pd=1 as=0.20638 ps=1.285 w=0.65 l=0.15 sa=1.465 sb=1.825
X11 a_97_199# A a_492_47# VNB sky130_fd_pr__nfet_01v8 ad=0.16087 pd=1.145 as=0.08775 ps=0.92 w=0.65 l=0.15 sa=2.385 sb=0.905
C0 C VPWR 0.03665f
C1 a_97_199# VPWR 0.09286f
C2 C Y 0
C3 VPB VPWR 0.13008f
C4 a_97_199# Y 0.06587f
C5 A B 0.14806f
C6 VPB Y 0.02031f
C7 A a_492_47# 0.00131f
C8 a_392_297# a_235_297# 0.00445f
C9 B VGND 0.04064f
C10 A VGND 0.05295f
C11 B a_235_47# 0.04641f
C12 a_492_47# VGND 0.00525f
C13 A a_235_47# 0.06428f
C14 a_235_47# a_492_47# 0.01001f
C15 a_235_47# VGND 0.1833f
C16 a_392_297# VPWR 0.12561f
C17 a_235_297# VPWR 0.02183f
C18 B C 0
C19 A C 0.02721f
C20 B a_97_199# 0.13793f
C21 a_392_297# Y 0.00211f
C22 A a_97_199# 0.09875f
C23 a_235_297# Y 0.00265f
C24 B VPB 0.07461f
C25 a_97_199# a_492_47# 0
C26 C VGND 0.00965f
C27 A VPB 0.07031f
C28 a_97_199# VGND 0.05238f
C29 C a_235_47# 0.02872f
C30 a_235_47# a_97_199# 0.0675f
C31 VPB VGND 0.01117f
C32 VPB a_235_47# 0.00165f
C33 Y VPWR 0.04745f
C34 C a_97_199# 0.01706f
C35 B a_392_297# 0.01293f
C36 A a_392_297# 0.03507f
C37 B a_235_297# 0.00676f
C38 C VPB 0.04342f
C39 A a_235_297# 0
C40 VPB a_97_199# 0.05358f
C41 a_235_297# VGND 0.00331f
C42 a_235_47# a_392_297# 0.00215f
C43 B VPWR 0.02814f
C44 A VPWR 0.03042f
C45 B Y 0.0025f
C46 A Y 0.0012f
C47 VGND VPWR 0.02758f
C48 C a_392_297# 0.00724f
C49 a_392_297# a_97_199# 0.08458f
C50 a_235_297# a_97_199# 0.02522f
C51 a_235_47# VPWR 0.00442f
C52 Y VGND 0.05784f
C53 VPB a_392_297# 0.00614f
C54 VGND VNB 0.5225f
C55 VPWR VNB 0.61454f
C56 Y VNB 0.19847f
C57 VPB VNB 0.87055f
C58 a_235_47# VNB 0.0352f
C59 a_392_297# VNB 0.12448f
C60 a_235_297# VNB 0.07009f
.ends
