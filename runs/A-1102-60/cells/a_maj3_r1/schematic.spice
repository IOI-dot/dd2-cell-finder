.subckt a_maj3_r1 A B C VGND VNB VPB VPWR Y
X0 _s1 A n1 VNB sky130_fd_pr__nfet_01v8 w=650000u l=150000u
X1 n1 B VGND VNB sky130_fd_pr__nfet_01v8 w=650000u l=150000u
X2 _s1 C n2 VNB sky130_fd_pr__nfet_01v8 w=650000u l=150000u
X3 n2 A VGND VNB sky130_fd_pr__nfet_01v8 w=650000u l=150000u
X4 n2 B VGND VNB sky130_fd_pr__nfet_01v8 w=650000u l=150000u
X5 Y _s1 VGND VNB sky130_fd_pr__nfet_01v8 w=650000u l=150000u
X6 _s1 A p1 VPB sky130_fd_pr__pfet_01v8_hvt w=1000000u l=150000u
X7 _s1 B p1 VPB sky130_fd_pr__pfet_01v8_hvt w=1000000u l=150000u
X8 p1 C VPWR VPB sky130_fd_pr__pfet_01v8_hvt w=1000000u l=150000u
X9 p1 A p2 VPB sky130_fd_pr__pfet_01v8_hvt w=1000000u l=150000u
X10 p2 B VPWR VPB sky130_fd_pr__pfet_01v8_hvt w=1000000u l=150000u
X11 Y _s1 VPWR VPB sky130_fd_pr__pfet_01v8_hvt w=1000000u l=150000u
.ends
