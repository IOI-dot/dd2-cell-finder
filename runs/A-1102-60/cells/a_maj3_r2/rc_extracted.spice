* NGSPICE file created from a_maj3_r2.ext - technology: sky130A

.subckt a_maj3_r2 A B C VGND VNB VPB VPWR Y
X0 a_343_47# C a_61_47# VNB sky130_fd_pr__nfet_01v8 ad=0.11375 pd=1 as=0.11375 ps=1 w=0.65 l=0.15 sa=1.26 sb=2.12
X1 VGND B a_443_47# VNB sky130_fd_pr__nfet_01v8 ad=0.25675 pd=1.44 as=0.08775 ps=0.92 w=0.65 l=0.15 sa=2.18 sb=1.2
X2 a_61_297# C VPWR VPB sky130_fd_pr__pfet_01v8_hvt ad=0.175 pd=1.35 as=0.175 ps=1.35 w=1 l=0.15 sa=1.26 sb=1.18
X3 a_61_47# B VGND VNB sky130_fd_pr__nfet_01v8 ad=0.11375 pd=1 as=0.11375 ps=1 w=0.65 l=0.15 sa=0.76 sb=2.62
X4 VPWR B a_143_297# VPB sky130_fd_pr__pfet_01v8_hvt ad=0.175 pd=1.35 as=0.175 ps=1.35 w=1 l=0.15 sa=0.76 sb=1.68
X5 Y a_343_47# VGND VNB sky130_fd_pr__nfet_01v8 ad=0.169 pd=1.82 as=0.25675 ps=1.44 w=0.65 l=0.15 sa=3.12 sb=0.26
X6 a_61_297# B a_343_47# VPB sky130_fd_pr__pfet_01v8_hvt ad=0.26 pd=2.52 as=0.135 ps=1.27 w=1 l=0.15 sa=2.18 sb=0.26
X7 VGND A a_61_47# VNB sky130_fd_pr__nfet_01v8 ad=0.11375 pd=1 as=0.169 ps=1.82 w=0.65 l=0.15 sa=0.26 sb=3.12
X8 a_143_297# A a_61_297# VPB sky130_fd_pr__pfet_01v8_hvt ad=0.175 pd=1.35 as=0.26 ps=2.52 w=1 l=0.15 sa=0.26 sb=2.18
X9 a_443_47# A a_343_47# VNB sky130_fd_pr__nfet_01v8 ad=0.08775 pd=0.92 as=0.11375 ps=1 w=0.65 l=0.15 sa=1.76 sb=1.62
X10 Y a_343_47# VPWR VPB sky130_fd_pr__pfet_01v8_hvt ad=0.26 pd=2.52 as=0.26 ps=2.52 w=1 l=0.15 sa=0.26 sb=0.26
X11 a_343_47# A a_61_297# VPB sky130_fd_pr__pfet_01v8_hvt ad=0.135 pd=1.27 as=0.175 ps=1.35 w=1 l=0.15 sa=1.76 sb=0.68
C0 a_61_47# a_61_297# 0.0024f
C1 A Y 0
C2 B Y 0.00113f
C3 a_443_47# Y 0
C4 A VPWR 0.02932f
C5 B VPWR 0.05224f
C6 VGND Y 0.04239f
C7 C a_61_297# 0.01321f
C8 a_143_297# a_343_47# 0
C9 a_61_297# a_343_47# 0.03881f
C10 VPWR VGND 0.02939f
C11 VPB a_61_297# 0.01812f
C12 a_61_47# VPWR 0.00136f
C13 C Y 0
C14 a_343_47# Y 0.05133f
C15 C VPWR 0.01425f
C16 VPB Y 0.01833f
C17 a_343_47# VPWR 0.04328f
C18 B A 0.12935f
C19 VPB VPWR 0.1248f
C20 B a_443_47# 0.00206f
C21 a_143_297# a_61_297# 0.01588f
C22 A VGND 0.02668f
C23 B VGND 0.06332f
C24 A a_61_47# 0.03386f
C25 a_443_47# VGND 0.00769f
C26 B a_61_47# 0.0394f
C27 a_61_47# a_443_47# 0
C28 a_61_47# VGND 0.10135f
C29 a_143_297# Y 0
C30 a_61_297# Y 0
C31 A C 0.05557f
C32 B C 0.04818f
C33 A a_343_47# 0.04161f
C34 a_143_297# VPWR 0.01146f
C35 B a_343_47# 0.10389f
C36 a_61_297# VPWR 0.18811f
C37 A VPB 0.07265f
C38 a_343_47# a_443_47# 0.00928f
C39 C VGND 0.01426f
C40 B VPB 0.06102f
C41 a_343_47# VGND 0.10322f
C42 C a_61_47# 0.01154f
C43 a_61_47# a_343_47# 0.02303f
C44 VPB VGND 0.01251f
C45 VPB a_61_47# 0.0017f
C46 VPWR Y 0.05941f
C47 C a_343_47# 0.00717f
C48 A a_143_297# 0.0046f
C49 B a_143_297# 0
C50 A a_61_297# 0.08906f
C51 C VPB 0.0278f
C52 B a_61_297# 0.03619f
C53 VPB a_343_47# 0.0596f
C54 a_143_297# VGND 0.00164f
C55 a_61_297# VGND 0.00334f
C56 VGND VNB 0.71265f
C57 Y VNB 0.16094f
C58 VPWR VNB 0.39355f
C59 VPB VNB 0.87055f
C60 a_443_47# VNB 0.06941f
C61 a_61_47# VNB 0.14155f
C62 a_61_297# VNB 0.0199f
.ends
