* NGSPICE file created from a_maj3_r0.ext - technology: sky130A

.subckt a_maj3_r0 A B C VGND VNB VPB VPWR Y
X0 Y a_145_47# VGND VNB sky130_fd_pr__nfet_01v8 ad=0.169 pd=1.82 as=0.16087 ps=1.145 w=0.65 l=0.15 sa=3.565 sb=0.26
X1 VGND B a_274_47# VNB sky130_fd_pr__nfet_01v8 ad=0.16087 pd=1.145 as=0.08775 ps=0.92 w=0.65 l=0.15 sa=1.325 sb=2.5
X2 a_145_297# C VPWR VPB sky130_fd_pr__pfet_01v8_hvt ad=0.2475 pd=1.495 as=0.26 ps=2.52 w=1 l=0.15 sa=0.26 sb=3.565
X3 VPWR B a_487_297# VPB sky130_fd_pr__pfet_01v8_hvt ad=0.2475 pd=1.495 as=0.4 ps=1.8 w=1 l=0.15 sa=2.92 sb=0.905
X4 a_63_47# A VGND VNB sky130_fd_pr__nfet_01v8 ad=0.26 pd=1.45 as=0.16087 ps=1.145 w=0.65 l=0.15 sa=1.97 sb=1.855
X5 a_145_47# C a_63_47# VNB sky130_fd_pr__nfet_01v8 ad=0.16087 pd=1.145 as=0.169 ps=1.82 w=0.65 l=0.15 sa=0.26 sb=3.565
X6 a_487_297# A a_145_297# VPB sky130_fd_pr__pfet_01v8_hvt ad=0.4 pd=1.8 as=0.2475 ps=1.495 w=1 l=0.15 sa=1.97 sb=1.855
X7 VGND B a_63_47# VNB sky130_fd_pr__nfet_01v8 ad=0.16087 pd=1.145 as=0.26 ps=1.45 w=0.65 l=0.15 sa=2.92 sb=0.905
X8 a_145_297# B a_145_47# VPB sky130_fd_pr__pfet_01v8_hvt ad=0.2475 pd=1.495 as=0.135 ps=1.27 w=1 l=0.15 sa=1.325 sb=2.5
X9 a_274_47# A a_145_47# VNB sky130_fd_pr__nfet_01v8 ad=0.08775 pd=0.92 as=0.16087 ps=1.145 w=0.65 l=0.15 sa=0.905 sb=2.92
X10 a_145_47# A a_145_297# VPB sky130_fd_pr__pfet_01v8_hvt ad=0.135 pd=1.27 as=0.2475 ps=1.495 w=1 l=0.15 sa=0.905 sb=2.92
X11 Y a_145_47# VPWR VPB sky130_fd_pr__pfet_01v8_hvt ad=0.26 pd=2.52 as=0.2475 ps=1.495 w=1 l=0.15 sa=3.565 sb=0.26
C0 a_487_297# Y 0.00158f
C1 a_145_297# Y 0
C2 A B 0.13193f
C3 C a_145_47# 0.00599f
C4 a_487_297# VPWR 0.02561f
C5 A a_145_47# 0.10595f
C6 a_145_297# VPWR 0.10683f
C7 B a_274_47# 0
C8 C VPB 0.04316f
C9 a_145_47# a_274_47# 0.00869f
C10 B VGND 0.14948f
C11 A VPB 0.08419f
C12 a_145_47# VGND 0.08157f
C13 B a_63_47# 0.10239f
C14 a_63_47# a_145_47# 0.0623f
C15 VPB VGND 0.01537f
C16 VPB a_63_47# 0.00309f
C17 VPWR Y 0.04345f
C18 B a_145_47# 0.11186f
C19 A a_487_297# 0.00533f
C20 C a_145_297# 0.00811f
C21 B VPB 0.08041f
C22 A a_145_297# 0.07717f
C23 VPB a_145_47# 0.06409f
C24 a_487_297# VGND 0.00218f
C25 a_145_297# VGND 0
C26 a_63_47# a_487_297# 0.00343f
C27 a_63_47# a_145_297# 0.00457f
C28 A Y 0
C29 C VPWR 0.03756f
C30 A VPWR 0.0327f
C31 VGND Y 0.04834f
C32 B a_487_297# 0.00283f
C33 B a_145_297# 0.01884f
C34 a_487_297# a_145_47# 0.03893f
C35 a_145_297# a_145_47# 0.12013f
C36 a_63_47# Y 0
C37 VPWR VGND 0.02835f
C38 VPB a_145_297# 0.00974f
C39 a_63_47# VPWR 0.01328f
C40 B Y 0.00362f
C41 a_145_47# Y 0.05814f
C42 B VPWR 0.0261f
C43 VPB Y 0.01489f
C44 a_145_47# VPWR 0.13089f
C45 A C 0.03015f
C46 VPB VPWR 0.14458f
C47 A a_274_47# 0
C48 a_487_297# a_145_297# 0.00558f
C49 C VGND 0.01178f
C50 A VGND 0.02118f
C51 C a_63_47# 0.03112f
C52 a_274_47# VGND 0.00734f
C53 A a_63_47# 0.09669f
C54 a_63_47# a_274_47# 0.00268f
C55 a_63_47# VGND 0.13252f
C56 VGND VNB 0.75995f
C57 Y VNB 0.14594f
C58 VPWR VNB 0.51291f
C59 VPB VNB 0.95915f
C60 a_274_47# VNB 0.08163f
C61 a_63_47# VNB 0.12201f
C62 a_145_297# VNB 0.06019f
.ends
