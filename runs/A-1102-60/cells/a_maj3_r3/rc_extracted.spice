* NGSPICE file created from a_maj3_r3.ext - technology: sky130A

.subckt a_maj3_r3 A B C VGND VNB VPB VPWR Y
X0 a_527_47# C a_77_199# VNB sky130_fd_pr__nfet_01v8 ad=0.11375 pd=1 as=0.15275 ps=1.12 w=0.65 l=0.15 sa=2.24 sb=1.26
X1 a_77_199# A a_319_47# VNB sky130_fd_pr__nfet_01v8 ad=0.15275 pd=1.12 as=0.08775 ps=0.92 w=0.65 l=0.15 sa=1.62 sb=1.88
X2 a_627_297# B VPWR VPB sky130_fd_pr__pfet_01v8_hvt ad=0.175 pd=1.35 as=0.175 ps=1.35 w=1 l=0.15 sa=1.8 sb=0.76
X3 a_319_47# B VGND VNB sky130_fd_pr__nfet_01v8 ad=0.08775 pd=0.92 as=0.25675 ps=1.44 w=0.65 l=0.15 sa=1.2 sb=2.3
X4 VGND a_77_199# Y VNB sky130_fd_pr__nfet_01v8 ad=0.25675 pd=1.44 as=0.169 ps=1.82 w=0.65 l=0.15 sa=0.26 sb=3.24
X5 VPWR C a_237_297# VPB sky130_fd_pr__pfet_01v8_hvt ad=0.175 pd=1.35 as=0.235 ps=1.47 w=1 l=0.15 sa=1.3 sb=1.26
X6 a_527_47# A VGND VNB sky130_fd_pr__nfet_01v8 ad=0.169 pd=1.82 as=0.11375 ps=1 w=0.65 l=0.15 sa=3.24 sb=0.26
X7 a_237_297# A a_77_199# VPB sky130_fd_pr__pfet_01v8_hvt ad=0.235 pd=1.47 as=0.135 ps=1.27 w=1 l=0.15 sa=0.68 sb=1.88
X8 VPWR a_77_199# Y VPB sky130_fd_pr__pfet_01v8_hvt ad=0.26 pd=2.52 as=0.26 ps=2.52 w=1 l=0.15 sa=0.26 sb=0.26
X9 a_77_199# B a_237_297# VPB sky130_fd_pr__pfet_01v8_hvt ad=0.135 pd=1.27 as=0.26 ps=2.52 w=1 l=0.15 sa=0.26 sb=2.3
X10 VGND B a_527_47# VNB sky130_fd_pr__nfet_01v8 ad=0.11375 pd=1 as=0.11375 ps=1 w=0.65 l=0.15 sa=2.74 sb=0.76
X11 a_237_297# A a_627_297# VPB sky130_fd_pr__pfet_01v8_hvt ad=0.26 pd=2.52 as=0.175 ps=1.35 w=1 l=0.15 sa=2.3 sb=0.26
C0 B VPWR 0.05253f
C1 A VPWR 0.02971f
C2 a_527_47# VPWR 0.00147f
C3 B Y 0.00703f
C4 A Y 0.00268f
C5 VGND VPWR 0.02726f
C6 C a_237_297# 0.01321f
C7 a_627_297# a_77_199# 0
C8 Y a_527_47# 0
C9 a_237_297# a_77_199# 0.03925f
C10 Y VGND 0.04598f
C11 VPB a_237_297# 0.01786f
C12 a_319_47# Y 0
C13 C VPWR 0.0143f
C14 a_77_199# VPWR 0.04246f
C15 C Y 0
C16 VPB VPWR 0.12003f
C17 a_77_199# Y 0.06512f
C18 A B 0.12968f
C19 B a_527_47# 0.03853f
C20 VPB Y 0.01941f
C21 A a_527_47# 0.03303f
C22 a_627_297# a_237_297# 0.01582f
C23 B VGND 0.06325f
C24 A VGND 0.02722f
C25 B a_319_47# 0.00206f
C26 a_527_47# VGND 0.10131f
C27 a_319_47# a_527_47# 0
C28 a_319_47# VGND 0.00767f
C29 a_627_297# VPWR 0.01146f
C30 a_237_297# VPWR 0.19479f
C31 B C 0.04818f
C32 A C 0.05251f
C33 B a_77_199# 0.10503f
C34 a_627_297# Y 0
C35 A a_77_199# 0.04102f
C36 a_237_297# Y 0.00236f
C37 C a_527_47# 0.00605f
C38 B VPB 0.06108f
C39 a_77_199# a_527_47# 0.02062f
C40 C VGND 0.01518f
C41 A VPB 0.07399f
C42 a_77_199# VGND 0.1076f
C43 VPB a_527_47# 0.00211f
C44 a_319_47# a_77_199# 0.00916f
C45 VPB VGND 0.01075f
C46 Y VPWR 0.06218f
C47 C a_77_199# 0.0104f
C48 A a_627_297# 0.0046f
C49 B a_237_297# 0.03707f
C50 C VPB 0.02928f
C51 A a_237_297# 0.08959f
C52 VPB a_77_199# 0.06014f
C53 a_237_297# a_527_47# 0.00456f
C54 a_627_297# VGND 0.00191f
C55 a_237_297# VGND 0.00345f
C56 VGND VNB 0.61377f
C57 VPWR VNB 0.4609f
C58 Y VNB 0.24161f
C59 VPB VNB 0.87055f
C60 a_527_47# VNB 0.06193f
C61 a_319_47# VNB 0.08161f
C62 a_627_297# VNB 0.06711f
C63 a_237_297# VNB 0.02125f
.ends
