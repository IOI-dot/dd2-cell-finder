* NGSPICE file created from a_xor2_r1.ext - technology: sky130A

.subckt a_xor2_r1 A B VGND VNB VPB VPWR Y
X0 a_309_21.t2 B.t0 VGND.t2 VNB.t4 sky130_fd_pr__nfet_01v8 ad=0.08775 pd=0.92 as=0.25675 ps=1.44 w=0.65 l=0.15 sa=2.12 sb=0.68
X1 a_309_21.t1 A.t2 a_527_297.t0 VPB.t1 sky130_fd_pr__pfet_01v8_hvt ad=0.26 pd=2.52 as=0.135 ps=1.27 w=1 l=0.15 sa=0.68 sb=0.26
X2 Y.t0 A.t1 a_155_47.t0 VNB.t0 sky130_fd_pr__nfet_01v8 ad=0.08775 pd=0.92 as=0.11375 ps=1 w=0.65 l=0.15 sa=0.76 sb=2.04
X3 Y.t1 a_309_21.t4 a_73_297.t1 VPB.t2 sky130_fd_pr__pfet_01v8_hvt ad=0.26 pd=2.52 as=0.135 ps=1.27 w=1 l=0.15 sa=1.18 sb=0.26
X4 a_527_297.t1 B.t2 VPWR.t0 VPB.t4 sky130_fd_pr__pfet_01v8_hvt ad=0.135 pd=1.27 as=0.26 ps=2.52 w=1 l=0.15 sa=0.26 sb=0.68
X5 a_73_297.t0 A.t3 VPWR.t2 VPB.t0 sky130_fd_pr__pfet_01v8_hvt ad=0.135 pd=1.27 as=0.175 ps=1.35 w=1 l=0.15 sa=0.76 sb=0.68
X6 a_155_47.t1 B.t1 VGND.t0 VNB.t3 sky130_fd_pr__nfet_01v8 ad=0.11375 pd=1 as=0.169 ps=1.82 w=0.65 l=0.15 sa=0.26 sb=2.54
X7 VGND.t3 a_309_21.t3 Y.t2 VNB.t2 sky130_fd_pr__nfet_01v8 ad=0.25675 pd=1.44 as=0.08775 ps=0.92 w=0.65 l=0.15 sa=1.18 sb=1.62
X8 VPWR.t1 B.t3 a_73_297.t2 VPB.t3 sky130_fd_pr__pfet_01v8_hvt ad=0.175 pd=1.35 as=0.26 ps=2.52 w=1 l=0.15 sa=0.26 sb=1.18
X9 VGND.t1 A.t0 a_309_21.t0 VNB.t1 sky130_fd_pr__nfet_01v8 ad=0.169 pd=1.82 as=0.08775 ps=0.92 w=0.65 l=0.15 sa=2.54 sb=0.26
R0 VGND.n1 VGND.n0 9.3005
R1 VGND.n3 VGND.n2 9.3005
R2 VGND.n5 VGND.n4 9.3005
R3 VGND.n7 VGND.n6 9.3005
R4 VGND VGND.n12 0.0226354
R5 VGND.n12 VGND.n1 0.120292
R6 VGND.n1 VGND.n3 0.120292
R7 VGND.n3 VGND.n5 0.120292
R8 VGND.n5 VGND.n7 0.120292
R9 VGND.n7 VGND.n8 1.05096
R10 VGND.n8 VGND.t1 172.135
R11 VGND.n12 VGND.n11 28.877
R12 VGND.n0 VGND.n11 15.0593
R13 VGND.n0 VGND.n2 34.6358
R14 VGND.n2 VGND.n4 34.6358
R15 VGND.n4 VGND.n6 34.6358
R16 VGND.n6 VGND.n10 1.50638
R17 VGND.n10 VGND.n8 39.8285
R18 VGND.n11 VGND.t0 290.289
R19 VGND.n10 VGND.n9 207.213
R20 VGND.n9 VGND.t3 72.9236
R21 VGND.n9 VGND.t2 72.9236
R22 Y.n0 Y.n1 185
R23 Y.n3 Y.n0 197.8
R24 Y.n3 Y 6.4005
R25 Y Y.n1 6.4005
R26 Y Y.n3 2.25932
R27 Y.n1 Y 242.447
R28 Y Y.n2 6.4005
R29 Y Y.n2 6.77697
R30 Y.t1 Y.n2 325.269
R31 Y.n0 Y.t0 24.9236
R32 Y.n0 Y.t2 24.9236
R33 VPWR VPWR.n0 0.280764
R34 VPWR.n0 VPWR.t0 269.904
R35 VPWR.n0 VPWR.n1 619.472
R36 VPWR.n1 VPWR.t1 34.4755
R37 VPWR.n1 VPWR.t2 34.4755
R38 A.n1 A.n0 152
R39 A A.n1 6.4005
R40 A.n3 A.n1 32.7726
R41 A.n3 A.n2 152
R42 A A.n3 6.4005
R43 A.n2 A.t0 158.064
R44 A.n2 A.t2 230.363
R45 A.n0 A.t1 169.237
R46 A.n0 A.t3 241.536
R47 B.n1 B.n0 152
R48 B B.n1 6.4005
R49 B.n3 B.n1 25.8577
R50 B B.n3 0.376971
R51 B.n3 B.n2 158.024
R52 B.n2 B.t0 169.237
R53 B.n2 B.t2 241.536
R54 B.n0 B.t1 169.237
R55 B.n0 B.t3 241.536
R56 VPB VPB.t3 328.505
R57 VPB.t3 VPB.t0 295.95
R58 VPB.t0 VPB.t2 248.599
R59 VPB.t2 VPB.t4 556.386
R60 VPB.t4 VPB.t1 248.599
R61 VNB VNB.t3 1580.58
R62 VNB.t3 VNB.t0 1423.95
R63 VNB.t0 VNB.t2 1196.12
R64 VNB.t2 VNB.t4 2677.02
R65 VNB.t4 VNB.t1 1196.12
R66 a_155_47.t0 a_155_47.t1 64.6159
R67 a_527_297.t0 a_527_297.t1 53.1905
R68 a_73_297.t0 a_73_297.n0 26.5955
R69 a_73_297.n0 a_73_297.t1 26.5955
R70 a_73_297.n0 a_73_297.t2 680.593
R71 a_309_21.t1 a_309_21.n0 267.952
R72 a_309_21.n0 a_309_21.n1 92.501
R73 a_309_21.n0 a_309_21.n2 231.308
R74 a_309_21.n2 a_309_21.t3 158.064
R75 a_309_21.n2 a_309_21.t4 230.363
R76 a_309_21.n1 a_309_21.t2 24.9236
R77 a_309_21.n1 a_309_21.t0 24.9236
C0 Y A 0.09864f
C1 VGND A 0.06054f
C2 B A 0.13203f
C3 VPB A 0.09498f
C4 VGND Y 0.07319f
C5 VPWR A 0.15691f
C6 Y B 0.11648f
C7 VPB Y 0.02527f
C8 VGND B 0.1076f
C9 VPB VGND 0.00883f
C10 VPB B 0.07084f
C11 Y VPWR 0.04588f
C12 VGND VPWR 0.00928f
C13 B VPWR 0.05497f
C14 VPB VPWR 0.124f
C15 VGND VNB 0.03297f
C16 Y VNB 0f
C17 VPWR VNB 0f
C18 A VNB 0f
C19 B VNB 0f
C20 VPB VNB 0.50195f
C21 a_309_21.t1 VNB 0.14451f
C22 a_309_21.n0 VNB 0.30796f
C23 a_309_21.n1 VNB 0.03101f
C24 a_309_21.t2 VNB 0.03742f
C25 a_309_21.t0 VNB 0.03668f
C26 a_309_21.n2 VNB 0.09094f
C27 a_73_297.t0 VNB 0.04804f
C28 a_73_297.n0 VNB 0.10144f
C29 a_73_297.t2 VNB 0.15648f
C30 a_73_297.t1 VNB 0.04393f
C31 a_527_297.t0 VNB 0.04684f
C32 a_527_297.t1 VNB 0.04781f
C33 a_155_47.t0 VNB 0.03489f
C34 a_155_47.t1 VNB 0.03531f
C35 VPB.t0 VNB 0.04543f
C36 VPB.t1 VNB 0.10865f
C37 VPB.t2 VNB 0.06716f
C38 VPB.t3 VNB 0.0521f
C39 VPB.t4 VNB 0.06716f
C40 B.n0 VNB 0.0616f
C41 B.n1 VNB 0.11136f
C42 B.n2 VNB 0.06214f
C43 B.n3 VNB 0.17778f
C44 A.n0 VNB 0.06044f
C45 A.n1 VNB 0.22025f
C46 A.n2 VNB 0.08337f
C47 A.n3 VNB 0.22081f
C48 VPWR.n0 VNB 0.32204f
C49 VPWR.t1 VNB 0.04602f
C50 VPWR.t2 VNB 0.04544f
C51 VPWR.n1 VNB 0.03139f
C52 VPWR.t0 VNB 0.07923f
C53 Y.n0 VNB 0.03409f
C54 Y.t0 VNB 0.03851f
C55 Y.t2 VNB 0.03551f
C56 Y.n1 VNB 0.11844f
C57 Y.t1 VNB 0.11982f
C58 Y.n2 VNB 0.04866f
C59 Y.n3 VNB 0.0583f
C60 VGND.n0 VNB 0.00631f
C61 VGND.n1 VNB 0.02482f
C62 VGND.n2 VNB 0.00879f
C63 VGND.n3 VNB 0.02482f
C64 VGND.n4 VNB 0.00879f
C65 VGND.n5 VNB 0.02482f
C66 VGND.n6 VNB 0.00459f
C67 VGND.n7 VNB 0.09368f
C68 VGND.n8 VNB 0.04497f
C69 VGND.t1 VNB 0.04105f
C70 VGND.t3 VNB 0.03325f
C71 VGND.t2 VNB 0.03667f
C72 VGND.n9 VNB 0.0295f
C73 VGND.n10 VNB 0.01406f
C74 VGND.t0 VNB 0.03973f
C75 VGND.n11 VNB 0.01691f
C76 VGND.n12 VNB 0.01936f
.ends
