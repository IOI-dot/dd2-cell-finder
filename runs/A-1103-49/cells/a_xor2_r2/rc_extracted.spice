* NGSPICE file created from a_xor2_r2.ext - technology: sky130A

.subckt a_xor2_r2 A B VGND VNB VPB VPWR Y
X0 a_139_297.t1 B.t3 VPWR.t2 VPB.t3 sky130_fd_pr__pfet_01v8_hvt ad=0.175 pd=1.35 as=0.26 ps=2.52 w=1 l=0.15 sa=0.26 sb=0.76
X1 a_527_47.t0 A.t0 Y.t0 VNB.t1 sky130_fd_pr__nfet_01v8 ad=0.11375 pd=1 as=0.11375 ps=1 w=0.65 l=0.15 sa=2.2 sb=0.76
X2 a_427_297.t2 B.t2 VPWR.t1 VPB.t4 sky130_fd_pr__pfet_01v8_hvt ad=0.26 pd=2.52 as=0.175 ps=1.35 w=1 l=0.15 sa=1.26 sb=0.26
X3 a_139_47.t2 B.t1 VGND.t0 VNB.t3 sky130_fd_pr__nfet_01v8 ad=0.11375 pd=1 as=0.169 ps=1.82 w=0.65 l=0.15 sa=0.26 sb=2.7
X4 Y.t1 a_139_47.t3 VGND.t3 VNB.t2 sky130_fd_pr__nfet_01v8 ad=0.11375 pd=1 as=0.25675 ps=1.44 w=0.65 l=0.15 sa=1.7 sb=1.26
X5 VPWR.t0 A.t2 a_427_297.t0 VPB.t1 sky130_fd_pr__pfet_01v8_hvt ad=0.175 pd=1.35 as=0.175 ps=1.35 w=1 l=0.15 sa=0.76 sb=0.76
X6 a_139_47.t0 A.t3 a_139_297.t0 VPB.t0 sky130_fd_pr__pfet_01v8_hvt ad=0.26 pd=2.52 as=0.175 ps=1.35 w=1 l=0.15 sa=0.76 sb=0.26
X7 a_427_297.t1 a_139_47.t4 Y.t2 VPB.t2 sky130_fd_pr__pfet_01v8_hvt ad=0.175 pd=1.35 as=0.26 ps=2.52 w=1 l=0.15 sa=0.26 sb=1.26
X8 VGND.t2 B.t0 a_527_47.t1 VNB.t4 sky130_fd_pr__nfet_01v8 ad=0.169 pd=1.82 as=0.11375 ps=1 w=0.65 l=0.15 sa=2.7 sb=0.26
X9 VGND.t1 A.t1 a_139_47.t1 VNB.t0 sky130_fd_pr__nfet_01v8 ad=0.25675 pd=1.44 as=0.11375 ps=1 w=0.65 l=0.15 sa=0.76 sb=2.2
R0 VGND.n1 VGND.n0 9.3005
R1 VGND.n3 VGND.n2 9.3005
R2 VGND VGND.n8 0.0226354
R3 VGND.n8 VGND.n1 0.120292
R4 VGND.n1 VGND.n3 0.120292
R5 VGND.n3 VGND.n4 0.170339
R6 VGND.n4 VGND.t2 303.339
R7 VGND.n8 VGND.n7 22.8534
R8 VGND.n7 VGND.n0 21.0829
R9 VGND.n0 VGND.n2 34.6358
R10 VGND.n2 VGND.n6 33.1299
R11 VGND.n4 VGND.n6 9.08385
R12 VGND.n7 VGND.t0 160.222
R13 VGND.n6 VGND.n5 207.213
R14 VGND.n5 VGND.t1 72.9236
R15 VGND.n5 VGND.t3 72.9236
R16 Y.n4 Y 6.8005
R17 Y.n1 Y.n0 185
R18 Y.n0 Y.n4 197.8
R19 Y Y.n4 6.4005
R20 Y Y.n1 6.4005
R21 Y.n1 Y.n3 227.388
R22 Y Y.n3 0.376971
R23 Y.n3 Y.n2 22.4932
R24 Y Y.n2 42.4117
R25 Y.n2 Y.t2 218.792
R26 Y.n0 Y.t1 32.3082
R27 Y.n0 Y.t0 32.3082
R28 VPWR VPWR.n0 0.0897645
R29 VPWR.n0 VPWR.n1 619.971
R30 VPWR.n1 VPWR.t0 34.4755
R31 VPWR.n1 VPWR.t1 34.4755
R32 VPWR.n0 VPWR.t2 270.154
R33 A A.n1 4.89462
R34 A.n1 A.n0 153.506
R35 A.n3 A.n1 19.6277
R36 A A.n3 0.376971
R37 A.n3 A.n2 158.024
R38 A.n2 A.t0 169.237
R39 A.n2 A.t2 241.536
R40 A.n0 A.t1 169.237
R41 A.n0 A.t3 241.536
R42 B.n1 B.n0 152
R43 B B.n1 6.4005
R44 B.n3 B.n1 26.7164
R45 B B.n3 0.376971
R46 B.n3 B.n2 158.024
R47 B.n2 B.t0 169.237
R48 B.n2 B.t2 241.536
R49 B.n0 B.t1 169.237
R50 B.n0 B.t3 241.536
R51 VPB VPB.t3 281.154
R52 VPB.t3 VPB.t0 295.95
R53 VPB.t0 VPB.t2 556.386
R54 VPB.t2 VPB.t1 295.95
R55 VPB.t1 VPB.t4 295.95
R56 VNB VNB.t3 1352.75
R57 VNB.t3 VNB.t0 1423.95
R58 VNB.t0 VNB.t2 2677.02
R59 VNB.t2 VNB.t1 1423.95
R60 VNB.t1 VNB.t4 1423.95
R61 a_527_47.t0 a_527_47.t1 64.6159
R62 a_427_297.n0 a_427_297.t1 34.4755
R63 a_427_297.t0 a_427_297.n0 34.4755
R64 a_427_297.n0 a_427_297.t2 998.452
R65 a_139_297.t0 a_139_297.t1 68.9505
R66 a_139_47.t0 a_139_47.n1 247.625
R67 a_139_47.n1 a_139_47.n2 191.154
R68 a_139_47.n2 a_139_47.t3 169.237
R69 a_139_47.n2 a_139_47.t4 241.536
R70 a_139_47.n1 a_139_47.n0 150.816
R71 a_139_47.n0 a_139_47.t2 32.3082
R72 a_139_47.n0 a_139_47.t1 32.3082
C0 VPB VGND 0.01074f
C1 VPB Y 0.02219f
C2 Y VGND 0.07562f
C3 A VPWR 0.02834f
C4 B VPWR 0.17924f
C5 VPB VPWR 0.12516f
C6 VGND VPWR 0.01781f
C7 Y VPWR 0.03503f
C8 A B 0.13438f
C9 VPB A 0.06634f
C10 A VGND 0.094f
C11 Y A 0.09082f
C12 VPB B 0.09f
C13 VGND B 0.05861f
C14 Y B 0.12927f
C15 VGND VNB 0.05497f
C16 Y VNB 0f
C17 VPWR VNB 0f
C18 A VNB 0f
C19 B VNB 0f
C20 VPB VNB 0.51122f
C21 a_139_47.t0 VNB 0.12328f
C22 a_139_47.n0 VNB 0.06619f
C23 a_139_47.t2 VNB 0.04047f
C24 a_139_47.t1 VNB 0.04186f
C25 a_139_47.n1 VNB 0.26185f
C26 a_139_47.n2 VNB 0.05543f
C27 a_139_297.t0 VNB 0.05536f
C28 a_139_297.t1 VNB 0.05344f
C29 a_427_297.t0 VNB 0.05571f
C30 a_427_297.n0 VNB 0.0884f
C31 a_427_297.t2 VNB 0.17143f
C32 a_427_297.t1 VNB 0.04905f
C33 a_527_47.t0 VNB 0.03576f
C34 a_527_47.t1 VNB 0.03437f
C35 VPB.t0 VNB 0.06687f
C36 VPB.t1 VNB 0.04644f
C37 VPB.t2 VNB 0.06687f
C38 VPB.t3 VNB 0.04528f
C39 VPB.t4 VNB 0.09845f
C40 B.n0 VNB 0.06002f
C41 B.n1 VNB 0.16474f
C42 B.n2 VNB 0.06054f
C43 B.n3 VNB 0.25959f
C44 A.n0 VNB 0.06399f
C45 A.n1 VNB 0.13107f
C46 A.n2 VNB 0.06442f
C47 A.n3 VNB 0.13277f
C48 VPWR.n0 VNB 0.39271f
C49 VPWR.t2 VNB 0.07603f
C50 VPWR.t0 VNB 0.04647f
C51 VPWR.t1 VNB 0.04455f
C52 VPWR.n1 VNB 0.03022f
C53 Y.n0 VNB 0.04179f
C54 Y.t1 VNB 0.03881f
C55 Y.t0 VNB 0.04362f
C56 Y.n1 VNB 0.10636f
C57 Y.n2 VNB 0.07033f
C58 Y.t2 VNB 0.11134f
C59 Y.n3 VNB 0.10954f
C60 Y.n4 VNB 0.03481f
C61 VGND.n0 VNB 0.0067f
C62 VGND.n1 VNB 0.02351f
C63 VGND.n2 VNB 0.00815f
C64 VGND.n3 VNB 0.04473f
C65 VGND.n4 VNB 0.1378f
C66 VGND.t2 VNB 0.03913f
C67 VGND.t1 VNB 0.03673f
C68 VGND.t3 VNB 0.03192f
C69 VGND.n5 VNB 0.02795f
C70 VGND.n6 VNB 0.01696f
C71 VGND.t0 VNB 0.03852f
C72 VGND.n7 VNB 0.02215f
C73 VGND.n8 VNB 0.01737f
.ends
