* NGSPICE file created from a_xor2_r0.ext - technology: sky130A

.subckt a_xor2_r0 A B VGND VNB VPB VPWR Y
X0 a_133_297.t0 B.t3 VPWR.t1 VPB.t0 sky130_fd_pr__pfet_01v8_hvt ad=0.175 pd=1.35 as=0.26 ps=2.52 w=1 l=0.15 sa=0.26 sb=0.76
X1 VGND.t3 a_133_47.t3 Y.t2 VNB.t4 sky130_fd_pr__nfet_01v8 ad=0.169 pd=1.82 as=0.08775 ps=0.92 w=0.65 l=0.15 sa=2.765 sb=0.26
X2 VGND.t1 A.t1 a_133_47.t2 VNB.t2 sky130_fd_pr__nfet_01v8 ad=0.25675 pd=1.44 as=0.11375 ps=1 w=0.65 l=0.15 sa=0.76 sb=2.265
X3 a_133_47.t0 B.t1 VGND.t0 VNB.t0 sky130_fd_pr__nfet_01v8 ad=0.11375 pd=1 as=0.169 ps=1.82 w=0.65 l=0.15 sa=0.26 sb=2.765
X4 a_421_47.t0 B.t0 VGND.t2 VNB.t1 sky130_fd_pr__nfet_01v8 ad=0.16087 pd=1.145 as=0.25675 ps=1.44 w=0.65 l=0.15 sa=1.7 sb=1.325
X5 Y.t1 a_133_47.t4 a_339_297.t2 VPB.t4 sky130_fd_pr__pfet_01v8_hvt ad=0.26 pd=2.52 as=0.135 ps=1.27 w=1 l=0.15 sa=1.325 sb=0.26
X6 a_133_47.t1 A.t3 a_133_297.t1 VPB.t2 sky130_fd_pr__pfet_01v8_hvt ad=0.26 pd=2.52 as=0.175 ps=1.35 w=1 l=0.15 sa=0.76 sb=0.26
X7 VPWR.t2 B.t2 a_339_297.t0 VPB.t1 sky130_fd_pr__pfet_01v8_hvt ad=0.2475 pd=1.495 as=0.26 ps=2.52 w=1 l=0.15 sa=0.26 sb=1.325
X8 a_339_297.t1 A.t2 VPWR.t0 VPB.t3 sky130_fd_pr__pfet_01v8_hvt ad=0.135 pd=1.27 as=0.2475 ps=1.495 w=1 l=0.15 sa=0.905 sb=0.68
X9 Y.t0 A.t0 a_421_47.t1 VNB.t3 sky130_fd_pr__nfet_01v8 ad=0.08775 pd=0.92 as=0.16087 ps=1.145 w=0.65 l=0.15 sa=2.345 sb=0.68
R0 VGND.n1 VGND.n0 9.3005
R1 VGND.n3 VGND.n2 9.3005
R2 VGND VGND.n8 0.0226354
R3 VGND.n8 VGND.n1 0.120292
R4 VGND.n1 VGND.n3 0.120292
R5 VGND.n3 VGND.n4 0.167666
R6 VGND.n4 VGND.t3 172.851
R7 VGND.n8 VGND.n7 20.5946
R8 VGND.n7 VGND.n0 23.3417
R9 VGND.n0 VGND.n2 34.6358
R10 VGND.n2 VGND.n6 30.8711
R11 VGND.n4 VGND.n6 11.3453
R12 VGND.n7 VGND.t0 290.289
R13 VGND.n6 VGND.n5 207.213
R14 VGND.n5 VGND.t1 72.9236
R15 VGND.n5 VGND.t2 72.9236
R16 Y.n1 Y.n0 185
R17 Y.n0 Y 194.892
R18 Y Y.n1 3.29747
R19 Y.n2 Y.n1 19.1793
R20 Y Y.n2 0.376971
R21 Y.n2 Y.t1 331.384
R22 Y.n0 Y.t0 24.9236
R23 Y.n0 Y.t2 24.9236
R24 VPWR VPWR.n0 0.0902668
R25 VPWR.n0 VPWR.n1 619.774
R26 VPWR.n1 VPWR.t2 49.2505
R27 VPWR.n1 VPWR.t0 48.2655
R28 VPWR.n0 VPWR.t1 888.514
R29 A.n1 A.n0 152
R30 A A.n1 6.4005
R31 A.n3 A.n1 117.46
R32 A A.n3 0.376971
R33 A.n3 A.n2 158.024
R34 A.n2 A.t0 158.064
R35 A.n2 A.t2 230.363
R36 A.n0 A.t1 169.237
R37 A.n0 A.t3 241.536
R38 B.n1 B.n0 152
R39 B B.n1 6.4005
R40 B.n3 B.n1 25.1648
R41 B B.n3 0.376971
R42 B.n3 B.n2 158.024
R43 B.n2 B.t0 158.064
R44 B.n2 B.t2 230.363
R45 B.n0 B.t1 169.237
R46 B.n0 B.t3 241.536
R47 VPB VPB.t0 263.397
R48 VPB.t0 VPB.t2 295.95
R49 VPB.t2 VPB.t1 556.386
R50 VPB.t1 VPB.t3 381.776
R51 VPB.t3 VPB.t4 248.599
R52 VNB VNB.t0 1267.31
R53 VNB.t0 VNB.t2 1423.95
R54 VNB.t2 VNB.t1 2677.02
R55 VNB.t1 VNB.t3 1836.89
R56 VNB.t3 VNB.t4 1196.12
R57 a_421_47.t0 a_421_47.t1 91.3851
R58 a_339_297.t0 a_339_297.n0 691.51
R59 a_339_297.n0 a_339_297.t1 26.5955
R60 a_339_297.n0 a_339_297.t2 26.5955
R61 a_133_297.t0 a_133_297.t1 68.9505
R62 a_133_47.t1 a_133_47.n0 218.792
R63 a_133_47.n0 a_133_47.n2 320.563
R64 a_133_47.n2 a_133_47.t3 169.237
R65 a_133_47.n2 a_133_47.t4 241.536
R66 a_133_47.n0 a_133_47.n1 292.216
R67 a_133_47.n1 a_133_47.t0 32.3082
R68 a_133_47.n1 a_133_47.t2 32.3082
C0 B VPB 0.07885f
C1 Y VPWR 0.02834f
C2 B A 0.14706f
C3 B VGND 0.065f
C4 B VPWR 0.0507f
C5 A VPB 0.07091f
C6 Y B 0.00905f
C7 VPB VGND 0.00993f
C8 VPWR VPB 0.11217f
C9 A VGND 0.08698f
C10 Y VPB 0.01789f
C11 VPWR A 0.02826f
C12 VPWR VGND 0.02289f
C13 Y A 0.02511f
C14 Y VGND 0.07531f
C15 VGND VNB 0.05427f
C16 Y VNB 0f
C17 VPWR VNB 0f
C18 A VNB 0f
C19 B VNB 0f
C20 VPB VNB 0.51358f
C21 a_133_47.t1 VNB 0.10814f
C22 a_133_47.n0 VNB 0.27887f
C23 a_133_47.n1 VNB 0.12865f
C24 a_133_47.t0 VNB 0.03978f
C25 a_133_47.t2 VNB 0.04033f
C26 a_133_47.n2 VNB 0.09244f
C27 a_133_297.t0 VNB 0.04833f
C28 a_133_297.t1 VNB 0.0491f
C29 a_339_297.t0 VNB 0.1568f
C30 a_339_297.n0 VNB 0.10398f
C31 a_339_297.t1 VNB 0.0473f
C32 a_339_297.t2 VNB 0.04278f
C33 a_421_47.t0 VNB 0.03897f
C34 a_421_47.t1 VNB 0.03952f
C35 VPB.t0 VNB 0.04306f
C36 VPB.t1 VNB 0.07222f
C37 VPB.t2 VNB 0.06561f
C38 VPB.t3 VNB 0.04853f
C39 VPB.t4 VNB 0.08976f
C40 B.n0 VNB 0.05848f
C41 B.n1 VNB 0.05453f
C42 B.n2 VNB 0.08117f
C43 B.n3 VNB 0.08756f
C44 A.n0 VNB 0.06f
C45 A.n1 VNB 0.0645f
C46 A.n2 VNB 0.08329f
C47 A.n3 VNB 0.0754f
C48 VPWR.n0 VNB 0.29935f
C49 VPWR.t1 VNB 0.06235f
C50 VPWR.t2 VNB 0.04623f
C51 VPWR.t0 VNB 0.04663f
C52 VPWR.n1 VNB 0.03533f
C53 Y.n0 VNB 0.02349f
C54 Y.t0 VNB 0.03263f
C55 Y.t2 VNB 0.02941f
C56 Y.n1 VNB 0.05427f
C57 Y.t1 VNB 0.08895f
C58 Y.n2 VNB 0.0722f
C59 VGND.n0 VNB 0.00698f
C60 VGND.n1 VNB 0.02354f
C61 VGND.n2 VNB 0.00789f
C62 VGND.n3 VNB 0.04312f
C63 VGND.n4 VNB 0.14555f
C64 VGND.t3 VNB 0.03695f
C65 VGND.t1 VNB 0.03536f
C66 VGND.t2 VNB 0.03449f
C67 VGND.n5 VNB 0.02798f
C68 VGND.n6 VNB 0.01616f
C69 VGND.t0 VNB 0.0377f
C70 VGND.n7 VNB 0.01644f
C71 VGND.n8 VNB 0.01698f
.ends
