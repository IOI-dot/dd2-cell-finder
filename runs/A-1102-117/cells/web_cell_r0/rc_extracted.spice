* NGSPICE file created from web_cell_r0.ext - technology: sky130A

.subckt web_cell_r0 A B C VGND VNB VPB VPWR Y
X0 VPWR.t1 B.t1 a_243_297.t3 VPB.t5 sky130_fd_pr__pfet_01v8_hvt ad=0.175 pd=1.35 as=0.175 ps=1.35 w=1 l=0.15 sa=1.26 sb=0.76
X1 Y.t0 a_325_297.t5 VPWR.t0 VPB.t0 sky130_fd_pr__pfet_01v8_hvt ad=0.26 pd=2.52 as=0.26 ps=2.52 w=1 l=0.15 sa=0.26 sb=0.26
X2 a_525_47.t1 B.t0 a_325_297.t3 VNB.t5 sky130_fd_pr__nfet_01v8 ad=0.11375 pd=1 as=0.11375 ps=1 w=0.65 l=0.15 sa=2.2 sb=1.7
X3 VGND.t2 C.t1 a_55_47.t0 VNB.t3 sky130_fd_pr__nfet_01v8 ad=0.25675 pd=1.44 as=0.169 ps=1.82 w=0.65 l=0.15 sa=0.26 sb=3.64
X4 Y.t1 a_325_297.t4 VGND.t3 VNB.t0 sky130_fd_pr__nfet_01v8 ad=0.169 pd=1.82 as=0.25675 ps=1.44 w=0.65 l=0.15 sa=3.64 sb=0.26
X5 a_325_297.t1 a_55_47.t2 a_325_47.t0 VNB.t1 sky130_fd_pr__nfet_01v8 ad=0.11375 pd=1 as=0.11375 ps=1 w=0.65 l=0.15 sa=1.7 sb=2.2
X6 a_243_297.t0 a_55_47.t3 a_325_297.t0 VPB.t1 sky130_fd_pr__pfet_01v8_hvt ad=0.175 pd=1.35 as=0.175 ps=1.35 w=1 l=0.15 sa=0.76 sb=1.26
X7 a_325_47.t1 A.t0 VGND.t0 VNB.t2 sky130_fd_pr__nfet_01v8 ad=0.11375 pd=1 as=0.25675 ps=1.44 w=0.65 l=0.15 sa=1.2 sb=2.7
X8 VPWR.t3 C.t3 a_55_47.t1 VPB.t3 sky130_fd_pr__pfet_01v8_hvt ad=0.26 pd=2.52 as=0.26 ps=2.52 w=1 l=0.15 sa=0.26 sb=0.26
X9 a_325_297.t2 A.t1 a_243_297.t1 VPB.t2 sky130_fd_pr__pfet_01v8_hvt ad=0.175 pd=1.35 as=0.26 ps=2.52 w=1 l=0.15 sa=0.26 sb=1.76
X10 a_243_297.t2 C.t2 VPWR.t2 VPB.t4 sky130_fd_pr__pfet_01v8_hvt ad=0.26 pd=2.52 as=0.175 ps=1.35 w=1 l=0.15 sa=1.76 sb=0.26
X11 VGND.t1 C.t0 a_525_47.t0 VNB.t4 sky130_fd_pr__nfet_01v8 ad=0.25675 pd=1.44 as=0.11375 ps=1 w=0.65 l=0.15 sa=2.7 sb=1.2
R0 VGND VGND.n0 0.247499
R1 VGND.n0 VGND.n1 217.367
R2 VGND.n0 VGND.n2 216.731
R3 VGND.n2 VGND.t2 72.9236
R4 VGND.n2 VGND.t0 72.9236
R5 VGND.n1 VGND.t1 72.9236
R6 VGND.n1 VGND.t3 72.9236
R7 Y Y.n0 6.4005
R8 Y.n1 Y.t0 227.356
R9 Y Y.n1 6.4005
R10 Y.n1 Y.n0 79.0593
R11 Y.n0 Y.t1 134.204
R12 VPWR.n2 VPWR.n1 9.3005
R13 VPWR.n4 VPWR.n3 9.3005
R14 VPWR.n6 VPWR.n5 9.3005
R15 VPWR.n8 VPWR.n7 9.3005
R16 VPWR VPWR.n0 0.121778
R17 VPWR.n0 VPWR.n2 0.141672
R18 VPWR.n2 VPWR.n4 0.120292
R19 VPWR.n4 VPWR.n6 0.120292
R20 VPWR.n6 VPWR.n8 0.120292
R21 VPWR.n8 VPWR.n9 0.71132
R22 VPWR.n9 VPWR.t0 268.404
R23 VPWR.n0 VPWR.n10 17.4473
R24 VPWR.n10 VPWR.n1 24.8476
R25 VPWR.n1 VPWR.n3 34.6358
R26 VPWR.n3 VPWR.n5 34.6358
R27 VPWR.n5 VPWR.n7 34.6358
R28 VPWR.n7 VPWR.n12 20.3299
R29 VPWR.n9 VPWR.n12 21.3429
R30 VPWR.n12 VPWR.n11 607.212
R31 VPWR.n11 VPWR.t1 34.4755
R32 VPWR.n11 VPWR.t2 34.4755
R33 VPWR.n10 VPWR.t3 876.193
R34 B B.n0 158.4
R35 B.n0 B.t0 169.237
R36 B.n0 B.t1 241.536
R37 A A.n0 158.4
R38 A.n0 A.t0 169.237
R39 A.n0 A.t1 241.536
R40 C.n1 C.n0 152
R41 C C.n1 6.4005
R42 C.n3 C.n1 21.6553
R43 C C.n3 0.376971
R44 C.n3 C.n2 158.024
R45 C.n2 C.t0 169.237
R46 C.n2 C.t2 241.536
R47 C.n0 C.t1 169.237
R48 C.n0 C.t3 241.536
R49 VPB VPB.t3 275.235
R50 VPB.t3 VPB.t2 556.386
R51 VPB.t2 VPB.t1 295.95
R52 VPB.t1 VPB.t5 295.95
R53 VPB.t5 VPB.t4 295.95
R54 VPB.t4 VPB.t0 556.386
R55 VNB VNB.t3 1324.27
R56 VNB.t3 VNB.t2 2677.02
R57 VNB.t2 VNB.t1 1423.95
R58 VNB.t1 VNB.t5 1423.95
R59 VNB.t5 VNB.t4 1423.95
R60 VNB.t4 VNB.t0 2677.02
R61 a_525_47.t0 a_525_47.t1 64.6159
R62 a_325_47.t0 a_325_47.t1 64.6159
R63 a_243_297.n0 a_243_297.n1 292.5
R64 a_243_297.t0 a_243_297.n0 34.4755
R65 a_243_297.n0 a_243_297.t3 34.4755
R66 a_243_297.n1 a_243_297.t2 391.104
R67 a_243_297.n1 a_243_297.t1 389.791
R68 a_325_297.n0 a_325_297.t2 34.4755
R69 a_325_297.t0 a_325_297.n0 34.4755
R70 a_325_297.n0 a_325_297.n2 725.048
R71 a_325_297.n2 a_325_297.n3 191.154
R72 a_325_297.n3 a_325_297.t4 169.237
R73 a_325_297.n3 a_325_297.t5 241.536
R74 a_325_297.n2 a_325_297.n1 188.464
R75 a_325_297.n1 a_325_297.t1 32.3082
R76 a_325_297.n1 a_325_297.t3 32.3082
R77 a_55_47.t1 a_55_47.n0 290.514
R78 a_55_47.n0 a_55_47.t0 193.728
R79 a_55_47.n0 a_55_47.n1 177.135
R80 a_55_47.n1 a_55_47.t2 169.237
R81 a_55_47.n1 a_55_47.t3 241.536
C0 B VPB 0.0282f
C1 Y VPB 0.01719f
C2 VPWR C 0.05215f
C3 VGND C 0.12703f
C4 VGND VPWR 0.02555f
C5 Y B 0
C6 C A 0.01745f
C7 VPB C 0.07151f
C8 VPWR A 0.00903f
C9 VPWR VPB 0.14622f
C10 VGND A 0.02002f
C11 VGND VPB 0.01366f
C12 B C 0.04552f
C13 Y C 0.00193f
C14 VPWR B 0.01535f
C15 VGND B 0.01018f
C16 Y VPWR 0.07048f
C17 VPB A 0.03412f
C18 VGND Y 0.04285f
C19 VGND VNB 0.12218f
C20 Y VNB 0f
C21 VPWR VNB 0f
C22 B VNB 0.01665f
C23 A VNB 0.03349f
C24 C VNB 0f
C25 VPB VNB 0.61477f
C26 a_55_47.t1 VNB 0.13228f
C27 a_55_47.n0 VNB 0.29728f
C28 a_55_47.n1 VNB 0.0551f
C29 a_55_47.t0 VNB 0.08977f
C30 a_325_297.t0 VNB 0.05219f
C31 a_325_297.n0 VNB 0.06896f
C32 a_325_297.n1 VNB 0.08015f
C33 a_325_297.t1 VNB 0.03567f
C34 a_325_297.t3 VNB 0.041f
C35 a_325_297.n2 VNB 0.22574f
C36 a_325_297.n3 VNB 0.05405f
C37 a_325_297.t2 VNB 0.05549f
C38 a_243_297.t0 VNB 0.04506f
C39 a_243_297.n0 VNB 0.04228f
C40 a_243_297.t1 VNB 0.09775f
C41 a_243_297.n1 VNB 0.16428f
C42 a_243_297.t2 VNB 0.10005f
C43 a_243_297.t3 VNB 0.05242f
C44 a_325_47.t0 VNB 0.03094f
C45 a_325_47.t1 VNB 0.03332f
C46 a_525_47.t0 VNB 0.03444f
C47 a_525_47.t1 VNB 0.03538f
C48 VPB.t0 VNB 0.11375f
C49 VPB.t1 VNB 0.04478f
C50 VPB.t2 VNB 0.06449f
C51 VPB.t3 VNB 0.06292f
C52 VPB.t4 VNB 0.06449f
C53 VPB.t5 VNB 0.04478f
C54 C.n0 VNB 0.06017f
C55 C.n1 VNB 0.15506f
C56 C.n2 VNB 0.0607f
C57 C.n3 VNB 0.17987f
C58 A.n0 VNB 0.05515f
C59 B.n0 VNB 0.06336f
C60 VPWR.n0 VNB 0.04129f
C61 VPWR.n1 VNB 0.01067f
C62 VPWR.n2 VNB 0.04039f
C63 VPWR.n3 VNB 0.01242f
C64 VPWR.n4 VNB 0.03508f
C65 VPWR.n5 VNB 0.01242f
C66 VPWR.n6 VNB 0.03508f
C67 VPWR.n7 VNB 0.00986f
C68 VPWR.n8 VNB 0.16065f
C69 VPWR.n9 VNB 0.08587f
C70 VPWR.t3 VNB 0.06749f
C71 VPWR.n10 VNB 0.02716f
C72 VPWR.t1 VNB 0.04526f
C73 VPWR.t2 VNB 0.04396f
C74 VPWR.n11 VNB 0.02811f
C75 VPWR.n12 VNB 0.02162f
C76 VPWR.t0 VNB 0.06835f
C77 Y.t1 VNB 0.04111f
C78 Y.n0 VNB 0.04433f
C79 Y.t0 VNB 0.06676f
C80 Y.n1 VNB 0.06056f
C81 VGND.n0 VNB 0.28408f
C82 VGND.t1 VNB 0.0353f
C83 VGND.t3 VNB 0.03137f
C84 VGND.n1 VNB 0.029f
C85 VGND.t2 VNB 0.0353f
C86 VGND.t0 VNB 0.0333f
C87 VGND.n2 VNB 0.02852f
.ends
