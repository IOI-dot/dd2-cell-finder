* NGSPICE file created from f_and2.ext - technology: sky130A

.subckt f_and2 A B VGND VNB VPB VPWR Y
X0 a_63_47# A VPWR VPB sky130_fd_pr__pfet_01v8_hvt ad=0.175 pd=1.35 as=0.26 ps=2.52 w=1 l=0.15 sa=0.26 sb=1.26
X1 VGND B a_145_47# VNB sky130_fd_pr__nfet_01v8 ad=0.11375 pd=1 as=0.11375 ps=1 w=0.65 l=0.15 sa=0.76 sb=0.76
X2 Y a_63_47# VPWR VPB sky130_fd_pr__pfet_01v8_hvt ad=0.26 pd=2.52 as=0.175 ps=1.35 w=1 l=0.15 sa=1.26 sb=0.26
X3 a_145_47# A a_63_47# VNB sky130_fd_pr__nfet_01v8 ad=0.11375 pd=1 as=0.169 ps=1.82 w=0.65 l=0.15 sa=0.26 sb=1.26
X4 VPWR B a_63_47# VPB sky130_fd_pr__pfet_01v8_hvt ad=0.175 pd=1.35 as=0.175 ps=1.35 w=1 l=0.15 sa=0.76 sb=0.76
X5 Y a_63_47# VGND VNB sky130_fd_pr__nfet_01v8 ad=0.169 pd=1.82 as=0.11375 ps=1 w=0.65 l=0.15 sa=1.26 sb=0.26
C0 Y a_63_47# 0.06794f
C1 VPB VGND 0.01088f
C2 A B 0.03085f
C3 VPB Y 0.01926f
C4 a_145_47# VPWR 0.0011f
C5 VGND B 0.0163f
C6 VPWR a_63_47# 0.13156f
C7 Y B 0.00102f
C8 A VGND 0.01326f
C9 A Y 0
C10 VPB VPWR 0.08707f
C11 a_145_47# a_63_47# 0.01222f
C12 VGND Y 0.04307f
C13 VPWR B 0.01712f
C14 A VPWR 0.03242f
C15 VPB a_63_47# 0.04361f
C16 VGND VPWR 0.02708f
C17 VPWR Y 0.04338f
C18 B a_63_47# 0.08866f
C19 A a_63_47# 0.03705f
C20 VPB B 0.02894f
C21 a_145_47# VGND 0.01019f
C22 a_145_47# Y 0
C23 VPB A 0.03484f
C24 VGND a_63_47# 0.08837f
C25 VGND VNB 0.33316f
C26 Y VNB 0.17565f
C27 VPWR VNB 0.40985f
C28 VPB VNB 0.51617f
C29 a_145_47# VNB 0.02845f
.ends
