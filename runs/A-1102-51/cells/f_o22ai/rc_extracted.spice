* NGSPICE file created from f_o22ai.ext - technology: sky130A

.subckt f_o22ai A B C D VGND VNB VPB VPWR Y
X0 a_241_297# A Y VPB sky130_fd_pr__pfet_01v8_hvt ad=0.175 pd=1.35 as=0.175 ps=1.35 w=1 l=0.15 sa=0.76 sb=1.26
X1 a_141_47# B Y VNB sky130_fd_pr__nfet_01v8 ad=0.11375 pd=1 as=0.11375 ps=1 w=0.65 l=0.15 sa=1.26 sb=0.76
X2 Y C a_59_297# VPB sky130_fd_pr__pfet_01v8_hvt ad=0.175 pd=1.35 as=0.26 ps=2.52 w=1 l=0.15 sa=0.26 sb=1.76
X3 Y A a_141_47# VNB sky130_fd_pr__nfet_01v8 ad=0.11375 pd=1 as=0.11375 ps=1 w=0.65 l=0.15 sa=0.76 sb=1.26
X4 a_59_297# D VPWR VPB sky130_fd_pr__pfet_01v8_hvt ad=0.26 pd=2.52 as=0.175 ps=1.35 w=1 l=0.15 sa=1.76 sb=0.26
X5 a_141_47# C VGND VNB sky130_fd_pr__nfet_01v8 ad=0.11375 pd=1 as=0.169 ps=1.82 w=0.65 l=0.15 sa=0.26 sb=1.76
X6 VPWR B a_241_297# VPB sky130_fd_pr__pfet_01v8_hvt ad=0.175 pd=1.35 as=0.175 ps=1.35 w=1 l=0.15 sa=1.26 sb=0.76
X7 VGND D a_141_47# VNB sky130_fd_pr__nfet_01v8 ad=0.169 pd=1.82 as=0.11375 ps=1 w=0.65 l=0.15 sa=1.76 sb=0.26
C0 C a_59_297# 0.02551f
C1 a_241_297# a_59_297# 0.01607f
C2 VPB a_59_297# 0.02092f
C3 Y C 0.00364f
C4 a_241_297# Y 0.00952f
C5 Y VPB 0.01829f
C6 a_141_47# C 0.00543f
C7 a_141_47# VPB 0
C8 VPWR D 0.0145f
C9 VGND VPWR 0.02983f
C10 VGND D 0.01657f
C11 VPWR B 0.01241f
C12 B D 0.03085f
C13 VGND B 0.00998f
C14 C VPB 0.03326f
C15 VPWR A 0.00944f
C16 VGND A 0.0109f
C17 A B 0.03085f
C18 VPWR a_59_297# 0.16713f
C19 a_59_297# D 0.01291f
C20 VGND a_59_297# 0.00699f
C21 VPWR Y 0.02036f
C22 a_59_297# B 0.01288f
C23 Y D 0.05496f
C24 VGND Y 0.03713f
C25 Y B 0.04223f
C26 A a_59_297# 0.01319f
C27 VPWR a_141_47# 0.00254f
C28 a_141_47# D 0.00212f
C29 VGND a_141_47# 0.11569f
C30 Y A 0.02578f
C31 a_141_47# B 0.0075f
C32 a_141_47# A 0.02061f
C33 VPWR a_241_297# 0.00429f
C34 VPWR C 0.0094f
C35 VGND C 0.02986f
C36 VGND a_241_297# 0.00148f
C37 VPWR VPB 0.07781f
C38 VPB D 0.03234f
C39 VGND VPB 0.01161f
C40 Y a_59_297# 0.08603f
C41 a_241_297# B 0
C42 VPB B 0.0282f
C43 A C 0.03085f
C44 a_241_297# A 0
C45 a_141_47# a_59_297# 0
C46 A VPB 0.0282f
C47 a_141_47# Y 0.05224f
C48 VGND VNB 0.39219f
C49 VPWR VNB 0.32769f
C50 Y VNB 0.16868f
C51 VPB VNB 0.60476f
C52 a_141_47# VNB 0.03538f
C53 a_241_297# VNB 0.02845f
C54 a_59_297# VNB 0.13485f
.ends
