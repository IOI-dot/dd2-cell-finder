* NGSPICE file created from a_a22oi_r3.ext - technology: sky130A

.subckt a_a22oi_r3 A B C D VGND VNB VPB VPWR Y
X0 a_237_47# B VGND VNB sky130_fd_pr__nfet_01v8 ad=0.08775 pd=0.92 as=0.11375 ps=1 w=0.65 l=0.15
X1 a_137_297# A Y VPB sky130_fd_pr__pfet_01v8_hvt ad=0.235 pd=1.47 as=0.135 ps=1.27 w=1 l=0.15
X2 VPWR C a_137_297# VPB sky130_fd_pr__pfet_01v8_hvt ad=0.26 pd=2.52 as=0.235 ps=1.47 w=1 l=0.15
X3 VGND D a_55_47# VNB sky130_fd_pr__nfet_01v8 ad=0.11375 pd=1 as=0.169 ps=1.82 w=0.65 l=0.15
X4 Y B a_137_297# VPB sky130_fd_pr__pfet_01v8_hvt ad=0.135 pd=1.27 as=0.175 ps=1.35 w=1 l=0.15
X5 a_137_297# D VPWR VPB sky130_fd_pr__pfet_01v8_hvt ad=0.175 pd=1.35 as=0.26 ps=2.52 w=1 l=0.15
X6 a_55_47# C Y VNB sky130_fd_pr__nfet_01v8 ad=0.169 pd=1.82 as=0.15275 ps=1.12 w=0.65 l=0.15
X7 Y A a_237_47# VNB sky130_fd_pr__nfet_01v8 ad=0.15275 pd=1.12 as=0.08775 ps=0.92 w=0.65 l=0.15
.ends
