* NGSPICE file created from a_a22oi_r0.ext - technology: sky130A

.subckt a_a22oi_r0 A B C D VGND VNB VPB VPWR Y
X0 a_59_297# A Y VPB sky130_fd_pr__pfet_01v8_hvt ad=0.175 pd=1.35 as=0.175 ps=1.35 w=1 l=0.15 sa=0.76 sb=1.26
X1 a_341_47# C Y VNB sky130_fd_pr__nfet_01v8 ad=0.11375 pd=1 as=0.11375 ps=1 w=0.65 l=0.15 sa=1.26 sb=0.76
X2 Y B a_59_297# VPB sky130_fd_pr__pfet_01v8_hvt ad=0.175 pd=1.35 as=0.26 ps=2.52 w=1 l=0.15 sa=0.26 sb=1.76
X3 Y A a_141_47# VNB sky130_fd_pr__nfet_01v8 ad=0.11375 pd=1 as=0.11375 ps=1 w=0.65 l=0.15 sa=0.76 sb=1.26
X4 a_59_297# D VPWR VPB sky130_fd_pr__pfet_01v8_hvt ad=0.26 pd=2.52 as=0.175 ps=1.35 w=1 l=0.15 sa=1.76 sb=0.26
X5 a_141_47# B VGND VNB sky130_fd_pr__nfet_01v8 ad=0.11375 pd=1 as=0.169 ps=1.82 w=0.65 l=0.15 sa=0.26 sb=1.76
X6 VPWR C a_59_297# VPB sky130_fd_pr__pfet_01v8_hvt ad=0.175 pd=1.35 as=0.175 ps=1.35 w=1 l=0.15 sa=1.26 sb=0.76
X7 VGND D a_341_47# VNB sky130_fd_pr__nfet_01v8 ad=0.169 pd=1.82 as=0.11375 ps=1 w=0.65 l=0.15 sa=1.76 sb=0.26
C0 B a_59_297# 0.02595f
C1 a_141_47# a_59_297# 0
C2 VPB a_59_297# 0.02149f
C3 Y B 0.00571f
C4 a_141_47# Y 0.00647f
C5 Y VPB 0.01829f
C6 VPWR D 0.0145f
C7 VGND VPWR 0.02983f
C8 VGND D 0.01659f
C9 VPWR C 0.01538f
C10 a_141_47# B 0
C11 C D 0.03085f
C12 VGND C 0.01406f
C13 B VPB 0.03326f
C14 VPWR A 0.00959f
C15 VGND A 0.02104f
C16 A C 0.03085f
C17 VPWR a_59_297# 0.16808f
C18 a_59_297# D 0.01281f
C19 VGND a_59_297# 0.00848f
C20 VPWR Y 0.02043f
C21 a_59_297# C 0.01345f
C22 Y D 0.05639f
C23 VGND Y 0.08044f
C24 Y C 0.04787f
C25 A a_59_297# 0.01404f
C26 VPWR a_341_47# 0.00115f
C27 VGND a_341_47# 0.01081f
C28 Y A 0.0289f
C29 VPWR a_141_47# 0.00158f
C30 VPWR B 0.0094f
C31 VGND B 0.03013f
C32 VGND a_141_47# 0.0158f
C33 VPWR VPB 0.07865f
C34 VPB D 0.03234f
C35 VGND VPB 0.01213f
C36 Y a_59_297# 0.09825f
C37 VPB C 0.0282f
C38 a_141_47# A 0.00229f
C39 A B 0.03085f
C40 A VPB 0.0282f
C41 a_341_47# Y 0.01189f
C42 VGND VNB 0.39233f
C43 VPWR VNB 0.32737f
C44 Y VNB 0.17365f
C45 VPB VNB 0.60476f
C46 a_341_47# VNB 0.02842f
C47 a_59_297# VNB 0.16355f
.ends
