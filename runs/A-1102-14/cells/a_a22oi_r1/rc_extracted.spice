* NGSPICE file created from a_a22oi_r1.ext - technology: sky130A

.subckt a_a22oi_r1 A B C D VGND VNB VPB VPWR Y
X0 a_59_297# C VPWR VPB sky130_fd_pr__pfet_01v8_hvt ad=0.175 pd=1.35 as=0.175 ps=1.35 w=1 l=0.15 sa=0.76 sb=1.26
X1 a_341_47# A Y VNB sky130_fd_pr__nfet_01v8 ad=0.11375 pd=1 as=0.11375 ps=1 w=0.65 l=0.15 sa=1.26 sb=0.76
X2 VPWR D a_59_297# VPB sky130_fd_pr__pfet_01v8_hvt ad=0.175 pd=1.35 as=0.26 ps=2.52 w=1 l=0.15 sa=0.26 sb=1.76
X3 Y C a_141_47# VNB sky130_fd_pr__nfet_01v8 ad=0.11375 pd=1 as=0.11375 ps=1 w=0.65 l=0.15 sa=0.76 sb=1.26
X4 a_59_297# B Y VPB sky130_fd_pr__pfet_01v8_hvt ad=0.26 pd=2.52 as=0.175 ps=1.35 w=1 l=0.15 sa=1.76 sb=0.26
X5 a_141_47# D VGND VNB sky130_fd_pr__nfet_01v8 ad=0.11375 pd=1 as=0.169 ps=1.82 w=0.65 l=0.15 sa=0.26 sb=1.76
X6 Y A a_59_297# VPB sky130_fd_pr__pfet_01v8_hvt ad=0.175 pd=1.35 as=0.175 ps=1.35 w=1 l=0.15 sa=1.26 sb=0.76
X7 VGND B a_341_47# VNB sky130_fd_pr__nfet_01v8 ad=0.169 pd=1.82 as=0.11375 ps=1 w=0.65 l=0.15 sa=1.76 sb=0.26
C0 a_141_47# C 0.00229f
C1 C D 0.03085f
C2 C VPB 0.02921f
C3 a_341_47# VPWR 0.00115f
C4 a_141_47# a_59_297# 0.00118f
C5 D a_59_297# 0.02805f
C6 VPB a_59_297# 0.0205f
C7 a_141_47# VPWR 0.00158f
C8 VPWR D 0.01514f
C9 VPWR VPB 0.07926f
C10 Y B 0.06157f
C11 VGND Y 0.07749f
C12 VGND B 0.01675f
C13 Y A 0.03498f
C14 a_141_47# D 0
C15 A B 0.03085f
C16 VGND A 0.0144f
C17 D VPB 0.03285f
C18 Y C 0.00699f
C19 VGND C 0.02126f
C20 C A 0.03085f
C21 Y a_59_297# 0.0658f
C22 a_59_297# B 0.01023f
C23 VGND a_59_297# 0.00977f
C24 Y VPWR 0.01517f
C25 a_59_297# A 0.0241f
C26 VPWR B 0.00918f
C27 VGND VPWR 0.0309f
C28 VPWR A 0.00979f
C29 C a_59_297# 0.02561f
C30 Y a_341_47# 0.01189f
C31 VGND a_341_47# 0.01081f
C32 VPWR C 0.01741f
C33 Y D 0.00288f
C34 Y a_141_47# 0.00537f
C35 VGND a_141_47# 0.0158f
C36 VGND D 0.03008f
C37 Y VPB 0.01768f
C38 VPB B 0.03259f
C39 VGND VPB 0.01208f
C40 VPWR a_59_297# 0.17068f
C41 VPB A 0.02959f
C42 VGND VNB 0.39232f
C43 Y VNB 0.14718f
C44 VPWR VNB 0.35917f
C45 VPB VNB 0.60476f
C46 a_341_47# VNB 0.02842f
C47 a_59_297# VNB 0.15796f
.ends
