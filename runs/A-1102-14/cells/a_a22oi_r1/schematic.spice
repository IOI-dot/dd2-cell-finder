.subckt a_a22oi_r1 A B C D VGND VNB VPB VPWR Y
X0 Y A n1 VNB sky130_fd_pr__nfet_01v8 w=650000u l=150000u
X1 n1 B VGND VNB sky130_fd_pr__nfet_01v8 w=650000u l=150000u
X2 Y C n2 VNB sky130_fd_pr__nfet_01v8 w=650000u l=150000u
X3 n2 D VGND VNB sky130_fd_pr__nfet_01v8 w=650000u l=150000u
X4 Y A p1 VPB sky130_fd_pr__pfet_01v8_hvt w=1000000u l=150000u
X5 Y B p1 VPB sky130_fd_pr__pfet_01v8_hvt w=1000000u l=150000u
X6 p1 C VPWR VPB sky130_fd_pr__pfet_01v8_hvt w=1000000u l=150000u
X7 p1 D VPWR VPB sky130_fd_pr__pfet_01v8_hvt w=1000000u l=150000u
.ends
