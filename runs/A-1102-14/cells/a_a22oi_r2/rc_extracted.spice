* NGSPICE file created from a_a22oi_r2.ext - technology: sky130A

.subckt a_a22oi_r2 A B C D VGND VNB VPB VPWR Y
X0 Y A a_129_297# VPB sky130_fd_pr__pfet_01v8_hvt ad=0.175 pd=1.35 as=0.235 ps=1.47 w=1 l=0.15 sa=0.88 sb=1.26
X1 VGND B a_253_47# VNB sky130_fd_pr__nfet_01v8 ad=0.11375 pd=1 as=0.11375 ps=1 w=0.65 l=0.15 sa=1.38 sb=0.76
X2 Y C a_47_47# VNB sky130_fd_pr__nfet_01v8 ad=0.15275 pd=1.12 as=0.169 ps=1.82 w=0.65 l=0.15 sa=0.26 sb=1.88
X3 a_129_297# C VPWR VPB sky130_fd_pr__pfet_01v8_hvt ad=0.235 pd=1.47 as=0.26 ps=2.52 w=1 l=0.15 sa=0.26 sb=1.88
X4 a_253_47# A Y VNB sky130_fd_pr__nfet_01v8 ad=0.11375 pd=1 as=0.15275 ps=1.12 w=0.65 l=0.15 sa=0.88 sb=1.26
X5 VPWR D a_129_297# VPB sky130_fd_pr__pfet_01v8_hvt ad=0.26 pd=2.52 as=0.175 ps=1.35 w=1 l=0.15 sa=1.88 sb=0.26
X6 a_129_297# B Y VPB sky130_fd_pr__pfet_01v8_hvt ad=0.175 pd=1.35 as=0.175 ps=1.35 w=1 l=0.15 sa=1.38 sb=0.76
X7 a_47_47# D VGND VNB sky130_fd_pr__nfet_01v8 ad=0.169 pd=1.82 as=0.11375 ps=1 w=0.65 l=0.15 sa=1.88 sb=0.26
C0 a_47_47# a_129_297# 0.00293f
C1 C a_129_297# 0.00501f
C2 VPB a_129_297# 0.00726f
C3 VPWR C 0.0173f
C4 a_47_47# VPWR 0.00767f
C5 VPWR VPB 0.09186f
C6 a_253_47# a_47_47# 0.01252f
C7 Y D 0
C8 VGND Y 0.01698f
C9 VGND D 0.0156f
C10 Y B 0.01106f
C11 a_47_47# C 0.00668f
C12 B D 0.03085f
C13 VGND B 0.01353f
C14 C VPB 0.03365f
C15 a_47_47# VPB 0.00227f
C16 Y A 0.02916f
C17 VGND A 0.01023f
C18 A B 0.03085f
C19 Y a_129_297# 0.08175f
C20 a_129_297# D 0.01365f
C21 VGND a_129_297# 0.00493f
C22 Y VPWR 0.03443f
C23 a_129_297# B 0.01906f
C24 VPWR D 0.02667f
C25 VGND VPWR 0.0301f
C26 VPWR B 0.01024f
C27 A a_129_297# 0.01223f
C28 Y a_253_47# 0.00247f
C29 VGND a_253_47# 0.00336f
C30 VPWR A 0.00991f
C31 a_253_47# B 0
C32 a_253_47# A 0
C33 Y a_47_47# 0.05524f
C34 Y C 0.05338f
C35 a_47_47# D 0.02662f
C36 VGND a_47_47# 0.16406f
C37 VGND C 0.00953f
C38 Y VPB 0.0167f
C39 VPB D 0.03382f
C40 VGND VPB 0.00954f
C41 VPWR a_129_297# 0.14541f
C42 a_47_47# B 0.0258f
C43 VPB B 0.02959f
C44 A C 0.02776f
C45 a_47_47# A 0.01586f
C46 A VPB 0.02993f
C47 a_253_47# VPWR 0
C48 VGND VNB 0.37608f
C49 Y VNB 0.13844f
C50 VPWR VNB 0.3728f
C51 VPB VNB 0.60476f
C52 a_253_47# VNB 0.02845f
C53 a_47_47# VNB 0.0888f
C54 a_129_297# VNB 0.08189f
.ends
