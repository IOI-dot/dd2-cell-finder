* NGSPICE file created from f_a21oi.ext - technology: sky130A

.subckt f_a21oi A B C VGND VNB VPB VPWR Y
X0 Y C a_27_297# VPB sky130_fd_pr__pfet_01v8_hvt ad=0.26 pd=2.52 as=0.135 ps=1.27 w=1 l=0.15 sa=1.16 sb=0.26
X1 a_27_297# A VPWR VPB sky130_fd_pr__pfet_01v8_hvt ad=0.135 pd=1.27 as=0.165 ps=1.33 w=1 l=0.15 sa=0.74 sb=0.68
X2 Y A a_109_47# VNB sky130_fd_pr__nfet_01v8 ad=0.08775 pd=0.92 as=0.10725 ps=0.98 w=0.65 l=0.15 sa=0.74 sb=0.68
X3 VGND C Y VNB sky130_fd_pr__nfet_01v8 ad=0.169 pd=1.82 as=0.08775 ps=0.92 w=0.65 l=0.15 sa=1.16 sb=0.26
X4 VPWR B a_27_297# VPB sky130_fd_pr__pfet_01v8_hvt ad=0.165 pd=1.33 as=0.26 ps=2.52 w=1 l=0.15 sa=0.26 sb=1.16
X5 a_109_47# B VGND VNB sky130_fd_pr__nfet_01v8 ad=0.10725 pd=0.98 as=0.169 ps=1.82 w=0.65 l=0.15 sa=0.26 sb=1.16
C0 VPWR a_27_297# 0.10851f
C1 VPB C 0.03719f
C2 a_109_47# a_27_297# 0.0018f
C3 Y VPWR 0.02718f
C4 VGND VPWR 0.02247f
C5 a_109_47# Y 0.0054f
C6 a_109_47# VGND 0.01205f
C7 A a_27_297# 0.02074f
C8 B a_27_297# 0.02478f
C9 A Y 0.02816f
C10 C a_27_297# 0.00699f
C11 A VGND 0.01738f
C12 a_109_47# VPWR 0.00149f
C13 Y B 0.00449f
C14 VGND B 0.02261f
C15 Y C 0.05733f
C16 VGND C 0.02467f
C17 VPB a_27_297# 0.01152f
C18 A VPWR 0.01526f
C19 VPWR B 0.01461f
C20 a_109_47# A 0.00114f
C21 Y VPB 0.01482f
C22 VPWR C 0.01344f
C23 VGND VPB 0.00769f
C24 A B 0.03636f
C25 VPWR VPB 0.04906f
C26 A C 0.02548f
C27 Y a_27_297# 0.04092f
C28 VGND a_27_297# 0.01012f
C29 A VPB 0.0261f
C30 VPB B 0.0302f
C31 VGND Y 0.0516f
C32 VGND VNB 0.28207f
C33 Y VNB 0.13189f
C34 VPWR VNB 0.28692f
C35 VPB VNB 0.42757f
C36 a_27_297# VNB 0.16652f
.ends
