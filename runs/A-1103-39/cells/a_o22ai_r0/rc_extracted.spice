* NGSPICE file created from a_o22ai_r0.ext - technology: sky130A

.subckt a_o22ai_r0 A B C D VGND VNB VPB VPWR Y
X0 a_241_297.t0 A.t1 Y.t1 VPB.t2 sky130_fd_pr__pfet_01v8_hvt ad=0.175 pd=1.35 as=0.175 ps=1.35 w=1 l=0.15 sa=0.76 sb=1.26
X1 a_141_47.t3 B.t0 Y.t0 VNB.t3 sky130_fd_pr__nfet_01v8 ad=0.11375 pd=1 as=0.11375 ps=1 w=0.65 l=0.15 sa=1.26 sb=0.76
X2 Y.t3 C.t1 a_59_297.t1 VPB.t1 sky130_fd_pr__pfet_01v8_hvt ad=0.175 pd=1.35 as=0.26 ps=2.52 w=1 l=0.15 sa=0.26 sb=1.76
X3 Y.t2 A.t0 a_141_47.t2 VNB.t2 sky130_fd_pr__nfet_01v8 ad=0.11375 pd=1 as=0.11375 ps=1 w=0.65 l=0.15 sa=0.76 sb=1.26
X4 a_59_297.t0 D.t1 VPWR.t0 VPB.t0 sky130_fd_pr__pfet_01v8_hvt ad=0.26 pd=2.52 as=0.175 ps=1.35 w=1 l=0.15 sa=1.76 sb=0.26
X5 a_141_47.t1 C.t0 VGND.t1 VNB.t1 sky130_fd_pr__nfet_01v8 ad=0.11375 pd=1 as=0.169 ps=1.82 w=0.65 l=0.15 sa=0.26 sb=1.76
X6 VPWR.t1 B.t1 a_241_297.t1 VPB.t3 sky130_fd_pr__pfet_01v8_hvt ad=0.175 pd=1.35 as=0.175 ps=1.35 w=1 l=0.15 sa=1.26 sb=0.76
X7 VGND.t0 D.t0 a_141_47.t0 VNB.t0 sky130_fd_pr__nfet_01v8 ad=0.169 pd=1.82 as=0.11375 ps=1 w=0.65 l=0.15 sa=1.76 sb=0.26
R0 VGND VGND.n0 0.101058
R1 VGND.n0 VGND.t0 303.503
R2 VGND.n0 VGND.t1 172.97
R3 VPWR VPWR.n0 619.918
R4 VPWR.n0 VPWR.t1 34.4755
R5 VPWR.n0 VPWR.t0 34.4755
R6 Y Y.n4 6.8005
R7 Y.n1 Y.n0 185
R8 Y Y.n4 4.0965
R9 Y.n4 Y.n1 0.2565
R10 Y.n3 Y.n2 585
R11 Y Y.n3 6.4005
R12 Y.n1 Y.n3 245.249
R13 Y Y.n3 6.77697
R14 Y.n2 Y.t3 34.4755
R15 Y.n2 Y.t1 34.4755
R16 Y.n0 Y.t2 32.3082
R17 Y.n0 Y.t0 32.3082
R18 D D.n0 158.4
R19 D.n0 D.t0 169.237
R20 D.n0 D.t1 241.536
R21 B B.n0 158.4
R22 B.n0 B.t0 169.237
R23 B.n0 B.t1 241.536
R24 A A.n0 158.4
R25 A.n0 A.t0 169.237
R26 A.n0 A.t1 241.536
R27 C C.n0 158.4
R28 C.n0 C.t0 169.237
R29 C.n0 C.t1 241.536
R30 VPB VPB.t1 287.072
R31 VPB.t1 VPB.t2 295.95
R32 VPB.t2 VPB.t3 295.95
R33 VPB.t3 VPB.t0 295.95
R34 VNB VNB.t1 1381.23
R35 VNB.t1 VNB.t2 1423.95
R36 VNB.t2 VNB.t3 1423.95
R37 VNB.t3 VNB.t0 1423.95
R38 a_141_47.n0 a_141_47.t3 32.3082
R39 a_141_47.t0 a_141_47.n0 32.3082
R40 a_141_47.n0 a_141_47.n1 343.555
R41 a_141_47.n1 a_141_47.t1 32.3082
R42 a_141_47.n1 a_141_47.t2 32.3082
R43 a_241_297.t0 a_241_297.t1 68.9505
R44 a_59_297.t0 a_59_297.t1 698.694
C0 VGND VPB 0.01161f
C1 Y D 0.05496f
C2 VPWR Y 0.02036f
C3 VPWR C 0.0094f
C4 VGND Y 0.03713f
C5 VGND C 0.02986f
C6 VPWR D 0.0145f
C7 B A 0.03085f
C8 VGND D 0.01657f
C9 VGND VPWR 0.02983f
C10 VPB A 0.0282f
C11 Y A 0.02578f
C12 C A 0.03085f
C13 VPWR A 0.00944f
C14 VGND A 0.0109f
C15 VPB B 0.0282f
C16 Y B 0.04223f
C17 D B 0.03085f
C18 Y VPB 0.01829f
C19 C VPB 0.03326f
C20 VPWR B 0.01241f
C21 VGND B 0.00998f
C22 D VPB 0.03234f
C23 Y C 0.00364f
C24 VPWR VPB 0.07781f
C25 VGND VNB 0.1793f
C26 VPWR VNB 0.4676f
C27 Y VNB 0f
C28 D VNB 0.049f
C29 B VNB 0.02053f
C30 A VNB 0.02262f
C31 C VNB 0.06302f
C32 VPB VNB 0.446f
C33 a_59_297.t0 VNB 0.18895f
C34 a_59_297.t1 VNB 0.22209f
C35 a_241_297.t0 VNB 0.04317f
C36 a_241_297.t1 VNB 0.044f
C37 a_141_47.t0 VNB 0.03406f
C38 a_141_47.n0 VNB 0.05863f
C39 a_141_47.n1 VNB 0.08912f
C40 a_141_47.t1 VNB 0.03098f
C41 a_141_47.t2 VNB 0.03471f
C42 a_141_47.t3 VNB 0.03531f
C43 VPB.t0 VNB 0.08558f
C44 VPB.t1 VNB 0.03939f
C45 VPB.t2 VNB 0.03999f
C46 VPB.t3 VNB 0.03999f
C47 C.n0 VNB 0.04509f
C48 A.n0 VNB 0.05551f
C49 B.n0 VNB 0.05718f
C50 D.n0 VNB 0.05368f
C51 Y.t2 VNB 0.03576f
C52 Y.t0 VNB 0.03636f
C53 Y.n0 VNB 0.0318f
C54 Y.n1 VNB 0.08841f
C55 Y.t3 VNB 0.04678f
C56 Y.t1 VNB 0.05194f
C57 Y.n2 VNB 0.04893f
C58 Y.n3 VNB 0.09264f
C59 Y.n4 VNB 0.00867f
C60 VPWR.t1 VNB 0.04199f
C61 VPWR.t0 VNB 0.04026f
C62 VPWR.n0 VNB 0.02832f
C63 VGND.n0 VNB 0.18758f
C64 VGND.t0 VNB 0.03813f
C65 VGND.t1 VNB 0.03628f
.ends
