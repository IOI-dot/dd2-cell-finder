* NGSPICE file created from a_maj3_r0.ext - technology: sky130A

.subckt a_maj3_r0 A B C VGND VNB VPB VPWR Y
X0 Y.t0 a_145_47.t4 VGND.t3 VNB.t0 sky130_fd_pr__nfet_01v8 ad=0.169 pd=1.82 as=0.16087 ps=1.145 w=0.65 l=0.15 sa=3.565 sb=0.26
X1 VGND.t1 B.t1 a_274_47.t0 VNB.t1 sky130_fd_pr__nfet_01v8 ad=0.16087 pd=1.145 as=0.08775 ps=0.92 w=0.65 l=0.15 sa=1.325 sb=2.5
X2 a_145_297.t1 C.t1 VPWR.t2 VPB.t3 sky130_fd_pr__pfet_01v8_hvt ad=0.2475 pd=1.495 as=0.26 ps=2.52 w=1 l=0.15 sa=0.26 sb=3.565
X3 VPWR.t0 B.t2 a_487_297.t0 VPB.t2 sky130_fd_pr__pfet_01v8_hvt ad=0.2475 pd=1.495 as=0.4 ps=1.8 w=1 l=0.15 sa=2.92 sb=0.905
X4 a_63_47.t2 A.t0 VGND.t2 VNB.t5 sky130_fd_pr__nfet_01v8 ad=0.26 pd=1.45 as=0.16087 ps=1.145 w=0.65 l=0.15 sa=1.97 sb=1.855
X5 a_145_47.t1 C.t0 a_63_47.t1 VNB.t3 sky130_fd_pr__nfet_01v8 ad=0.16087 pd=1.145 as=0.169 ps=1.82 w=0.65 l=0.15 sa=0.26 sb=3.565
X6 a_487_297.t1 A.t2 a_145_297.t3 VPB.t5 sky130_fd_pr__pfet_01v8_hvt ad=0.4 pd=1.8 as=0.2475 ps=1.495 w=1 l=0.15 sa=1.97 sb=1.855
X7 VGND.t0 B.t0 a_63_47.t0 VNB.t2 sky130_fd_pr__nfet_01v8 ad=0.16087 pd=1.145 as=0.26 ps=1.45 w=0.65 l=0.15 sa=2.92 sb=0.905
X8 a_145_297.t0 B.t3 a_145_47.t0 VPB.t1 sky130_fd_pr__pfet_01v8_hvt ad=0.2475 pd=1.495 as=0.135 ps=1.27 w=1 l=0.15 sa=1.325 sb=2.5
X9 a_274_47.t1 A.t1 a_145_47.t3 VNB.t4 sky130_fd_pr__nfet_01v8 ad=0.08775 pd=0.92 as=0.16087 ps=1.145 w=0.65 l=0.15 sa=0.905 sb=2.92
X10 a_145_47.t2 A.t3 a_145_297.t2 VPB.t4 sky130_fd_pr__pfet_01v8_hvt ad=0.135 pd=1.27 as=0.2475 ps=1.495 w=1 l=0.15 sa=0.905 sb=2.92
X11 Y.t1 a_145_47.t5 VPWR.t1 VPB.t0 sky130_fd_pr__pfet_01v8_hvt ad=0.26 pd=2.52 as=0.2475 ps=1.495 w=1 l=0.15 sa=3.565 sb=0.26
R0 VGND VGND.n0 0.51856
R1 VGND.n0 VGND.n1 133.29
R2 VGND.n0 VGND.n2 215.294
R3 VGND.n2 VGND.t1 45.2313
R4 VGND.n2 VGND.t2 46.1543
R5 VGND.n1 VGND.t0 46.1543
R6 VGND.n1 VGND.t3 45.2313
R7 Y Y.n0 61.405
R8 Y Y.t1 232.07
R9 Y Y.n0 1.64144
R10 Y.n0 Y.t0 133.386
R11 VPWR VPWR.n0 0.0944925
R12 VPWR.n0 VPWR.n1 620.229
R13 VPWR.n1 VPWR.t0 49.2505
R14 VPWR.n1 VPWR.t1 48.2655
R15 VPWR.n0 VPWR.t2 270.312
R16 B.n1 B.n0 152
R17 B B.n1 6.4005
R18 B.n3 B.n2 152
R19 B B.n3 6.4005
R20 B.n3 B.n1 187.859
R21 B.n2 B.t0 158.064
R22 B.n2 B.t2 230.363
R23 B.n0 B.t1 158.064
R24 B.n0 B.t3 230.363
R25 A.n1 A.n0 152
R26 A A.n1 6.4005
R27 A.n3 A.n1 25.3604
R28 A A.n3 0.376971
R29 A.n3 A.n2 158.024
R30 A.n2 A.t0 158.064
R31 A.n2 A.t2 230.363
R32 A.n0 A.t1 158.064
R33 A.n0 A.t3 230.363
R34 C C.n0 158.4
R35 C.n0 C.t0 158.064
R36 C.n0 C.t1 230.363
R37 VPB VPB.t3 298.911
R38 VPB.t3 VPB.t4 381.776
R39 VPB.t4 VPB.t1 248.599
R40 VPB.t1 VPB.t5 381.776
R41 VPB.t5 VPB.t2 562.306
R42 VPB.t2 VPB.t0 381.776
R43 VNB VNB.t3 1438.19
R44 VNB.t3 VNB.t4 1836.89
R45 VNB.t4 VNB.t1 1196.12
R46 VNB.t1 VNB.t5 1836.89
R47 VNB.t5 VNB.t2 2705.5
R48 VNB.t2 VNB.t0 1836.89
R49 a_274_47.t0 a_274_47.t1 49.8467
R50 a_63_47.n0 a_63_47.t2 73.8467
R51 a_63_47.t0 a_63_47.n0 73.8467
R52 a_63_47.n0 a_63_47.t1 345.861
R53 a_487_297.t0 a_487_297.t1 157.601
R54 a_145_297.t0 a_145_297.n0 48.2655
R55 a_145_297.n0 a_145_297.t3 49.2505
R56 a_145_297.n0 a_145_297.n1 812.289
R57 a_145_297.n1 a_145_297.t1 49.2505
R58 a_145_297.n1 a_145_297.t2 48.2655
R59 a_145_47.n1 a_145_47.n0 193.548
R60 a_145_47.n1 a_145_47.t2 26.5955
R61 a_145_47.t0 a_145_47.n1 26.5955
R62 a_145_47.n0 a_145_47.n3 190.436
R63 a_145_47.n3 a_145_47.t1 46.1543
R64 a_145_47.n3 a_145_47.t3 45.2313
R65 a_145_47.n0 a_145_47.n2 349.072
R66 a_145_47.n2 a_145_47.t4 158.064
R67 a_145_47.n2 a_145_47.t5 230.363
C0 A VGND 0.02118f
C1 C VPB 0.04316f
C2 Y B 0.00362f
C3 VPB VGND 0.01537f
C4 VGND B 0.14948f
C5 A VPWR 0.0327f
C6 VGND Y 0.04834f
C7 VPB VPWR 0.14458f
C8 C VGND 0.01178f
C9 VPWR B 0.0261f
C10 Y VPWR 0.04345f
C11 A VPB 0.08419f
C12 C VPWR 0.03756f
C13 A B 0.13193f
C14 VGND VPWR 0.02835f
C15 A Y 0
C16 VPB B 0.08041f
C17 A C 0.03015f
C18 VPB Y 0.01489f
C19 VGND VNB 0.17254f
C20 Y VNB 0.03805f
C21 VPWR VNB 0f
C22 B VNB 0f
C23 A VNB 0f
C24 C VNB 0.05744f
C25 VPB VNB 0.60803f
C26 a_145_47.t0 VNB 0.05524f
C27 a_145_47.n0 VNB 0.30211f
C28 a_145_47.n1 VNB 0.04832f
C29 a_145_47.n2 VNB 0.13291f
C30 a_145_47.n3 VNB 0.10911f
C31 a_145_47.t1 VNB 0.04603f
C32 a_145_47.t3 VNB 0.05037f
C33 a_145_47.t2 VNB 0.05467f
C34 a_145_297.t0 VNB 0.05837f
C35 a_145_297.n0 VNB 0.08838f
C36 a_145_297.n1 VNB 0.15482f
C37 a_145_297.t1 VNB 0.05154f
C38 a_145_297.t2 VNB 0.0578f
C39 a_145_297.t3 VNB 0.05835f
C40 a_487_297.t0 VNB 0.07415f
C41 a_487_297.t1 VNB 0.07358f
C42 a_63_47.t0 VNB 0.06206f
C43 a_63_47.n0 VNB 0.18404f
C44 a_63_47.t1 VNB 0.20729f
C45 a_63_47.t2 VNB 0.06165f
C46 a_274_47.t0 VNB 0.03249f
C47 a_274_47.t1 VNB 0.03208f
C48 VPB.t0 VNB 0.10681f
C49 VPB.t1 VNB 0.04914f
C50 VPB.t2 VNB 0.07359f
C51 VPB.t3 VNB 0.05306f
C52 VPB.t4 VNB 0.04914f
C53 VPB.t5 VNB 0.07359f
C54 C.n0 VNB 0.06769f
C55 A.n0 VNB 0.08629f
C56 A.n1 VNB 0.07138f
C57 A.n2 VNB 0.08684f
C58 A.n3 VNB 0.11452f
C59 B.n0 VNB 0.08789f
C60 B.n1 VNB 0.1131f
C61 B.n2 VNB 0.08789f
C62 B.n3 VNB 0.10579f
C63 VPWR.n0 VNB 0.4373f
C64 VPWR.t2 VNB 0.06463f
C65 VPWR.t0 VNB 0.04975f
C66 VPWR.t1 VNB 0.04459f
C67 VPWR.n1 VNB 0.0374f
C68 Y.n0 VNB 0.02001f
C69 Y.t0 VNB 0.04227f
C70 Y.t1 VNB 0.06939f
C71 VGND.n0 VNB 0.30313f
C72 VGND.n1 VNB 0.02705f
C73 VGND.t0 VNB 0.0332f
C74 VGND.t3 VNB 0.02953f
C75 VGND.t1 VNB 0.03299f
C76 VGND.t2 VNB 0.03279f
C77 VGND.n2 VNB 0.02243f
.ends
