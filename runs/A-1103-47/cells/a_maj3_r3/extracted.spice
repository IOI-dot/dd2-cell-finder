* NGSPICE file created from a_maj3_r3.ext - technology: sky130A

.subckt a_maj3_r3 A B C VGND VNB VPB VPWR Y
X0 a_527_47# C a_77_199# VNB sky130_fd_pr__nfet_01v8 ad=0.11375 pd=1 as=0.15275 ps=1.12 w=0.65 l=0.15
X1 a_77_199# A a_319_47# VNB sky130_fd_pr__nfet_01v8 ad=0.15275 pd=1.12 as=0.08775 ps=0.92 w=0.65 l=0.15
X2 a_627_297# B VPWR VPB sky130_fd_pr__pfet_01v8_hvt ad=0.175 pd=1.35 as=0.175 ps=1.35 w=1 l=0.15
X3 a_319_47# B VGND VNB sky130_fd_pr__nfet_01v8 ad=0.08775 pd=0.92 as=0.25675 ps=1.44 w=0.65 l=0.15
X4 VGND a_77_199# Y VNB sky130_fd_pr__nfet_01v8 ad=0.25675 pd=1.44 as=0.169 ps=1.82 w=0.65 l=0.15
X5 VPWR C a_237_297# VPB sky130_fd_pr__pfet_01v8_hvt ad=0.175 pd=1.35 as=0.235 ps=1.47 w=1 l=0.15
X6 a_527_47# A VGND VNB sky130_fd_pr__nfet_01v8 ad=0.169 pd=1.82 as=0.11375 ps=1 w=0.65 l=0.15
X7 a_237_297# A a_77_199# VPB sky130_fd_pr__pfet_01v8_hvt ad=0.235 pd=1.47 as=0.135 ps=1.27 w=1 l=0.15
X8 VPWR a_77_199# Y VPB sky130_fd_pr__pfet_01v8_hvt ad=0.26 pd=2.52 as=0.26 ps=2.52 w=1 l=0.15
X9 a_77_199# B a_237_297# VPB sky130_fd_pr__pfet_01v8_hvt ad=0.135 pd=1.27 as=0.26 ps=2.52 w=1 l=0.15
X10 VGND B a_527_47# VNB sky130_fd_pr__nfet_01v8 ad=0.11375 pd=1 as=0.11375 ps=1 w=0.65 l=0.15
X11 a_237_297# A a_627_297# VPB sky130_fd_pr__pfet_01v8_hvt ad=0.26 pd=2.52 as=0.175 ps=1.35 w=1 l=0.15
.ends
