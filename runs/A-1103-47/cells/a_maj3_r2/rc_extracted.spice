* NGSPICE file created from a_maj3_r2.ext - technology: sky130A

.subckt a_maj3_r2 A B C VGND VNB VPB VPWR Y
X0 a_343_47.t0 C.t0 a_61_47.t0 VNB.t0 sky130_fd_pr__nfet_01v8 ad=0.11375 pd=1 as=0.11375 ps=1 w=0.65 l=0.15 sa=1.26 sb=2.12
X1 VGND.t0 B.t0 a_443_47.t1 VNB.t5 sky130_fd_pr__nfet_01v8 ad=0.25675 pd=1.44 as=0.08775 ps=0.92 w=0.65 l=0.15 sa=2.18 sb=1.2
X2 a_61_297.t0 C.t1 VPWR.t0 VPB.t0 sky130_fd_pr__pfet_01v8_hvt ad=0.175 pd=1.35 as=0.175 ps=1.35 w=1 l=0.15 sa=1.26 sb=1.18
X3 a_61_47.t2 B.t1 VGND.t1 VNB.t4 sky130_fd_pr__nfet_01v8 ad=0.11375 pd=1 as=0.11375 ps=1 w=0.65 l=0.15 sa=0.76 sb=2.62
X4 VPWR.t1 B.t3 a_143_297.t1 VPB.t4 sky130_fd_pr__pfet_01v8_hvt ad=0.175 pd=1.35 as=0.175 ps=1.35 w=1 l=0.15 sa=0.76 sb=1.68
X5 Y.t1 a_343_47.t4 VGND.t3 VNB.t1 sky130_fd_pr__nfet_01v8 ad=0.169 pd=1.82 as=0.25675 ps=1.44 w=0.65 l=0.15 sa=3.12 sb=0.26
X6 a_61_297.t3 B.t2 a_343_47.t3 VPB.t5 sky130_fd_pr__pfet_01v8_hvt ad=0.26 pd=2.52 as=0.135 ps=1.27 w=1 l=0.15 sa=2.18 sb=0.26
X7 VGND.t2 A.t1 a_61_47.t1 VNB.t2 sky130_fd_pr__nfet_01v8 ad=0.11375 pd=1 as=0.169 ps=1.82 w=0.65 l=0.15 sa=0.26 sb=3.12
X8 a_143_297.t0 A.t3 a_61_297.t2 VPB.t2 sky130_fd_pr__pfet_01v8_hvt ad=0.175 pd=1.35 as=0.26 ps=2.52 w=1 l=0.15 sa=0.26 sb=2.18
X9 a_443_47.t0 A.t0 a_343_47.t2 VNB.t3 sky130_fd_pr__nfet_01v8 ad=0.08775 pd=0.92 as=0.11375 ps=1 w=0.65 l=0.15 sa=1.76 sb=1.62
X10 Y.t0 a_343_47.t5 VPWR.t2 VPB.t1 sky130_fd_pr__pfet_01v8_hvt ad=0.26 pd=2.52 as=0.26 ps=2.52 w=1 l=0.15 sa=0.26 sb=0.26
X11 a_343_47.t1 A.t2 a_61_297.t1 VPB.t3 sky130_fd_pr__pfet_01v8_hvt ad=0.135 pd=1.27 as=0.175 ps=1.35 w=1 l=0.15 sa=1.76 sb=0.68
R0 VGND VGND.n0 0.201903
R1 VGND.n0 VGND.n1 216.093
R2 VGND.n0 VGND.n2 219.542
R3 VGND.n2 VGND.t2 32.3082
R4 VGND.n2 VGND.t1 32.3082
R5 VGND.n1 VGND.t0 72.9236
R6 VGND.n1 VGND.t3 72.9236
R7 Y Y.n0 6.4005
R8 Y.n1 Y.t0 227.356
R9 Y Y.n1 6.4005
R10 Y.n1 Y.n0 79.0593
R11 Y.n0 Y.t1 134.204
R12 VPWR VPWR.n0 0.337366
R13 VPWR.n0 VPWR.t2 359.938
R14 VPWR.n0 VPWR.n1 619.607
R15 VPWR.n1 VPWR.t1 34.4755
R16 VPWR.n1 VPWR.t0 34.4755
R17 C C.n0 158.4
R18 C.n0 C.t0 169.237
R19 C.n0 C.t1 241.536
R20 B.n1 B.n0 152
R21 B B.n1 6.4005
R22 B.n3 B.n1 25.374
R23 B B.n3 0.376971
R24 B.n3 B.n2 158.024
R25 B.n2 B.t0 169.237
R26 B.n2 B.t2 241.536
R27 B.n0 B.t1 169.237
R28 B.n0 B.t3 241.536
R29 A.n1 A.n0 152
R30 A A.n1 3.29747
R31 A.n3 A.n2 152
R32 A A.n3 3.29747
R33 A.n3 A.n1 133.089
R34 A.n2 A.t0 169.237
R35 A.n2 A.t2 241.536
R36 A.n0 A.t1 169.237
R37 A.n0 A.t3 241.536
R38 VPB VPB.t2 292.991
R39 VPB.t2 VPB.t4 295.95
R40 VPB.t4 VPB.t0 295.95
R41 VPB.t0 VPB.t3 295.95
R42 VPB.t3 VPB.t5 248.599
R43 VPB.t5 VPB.t1 556.386
R44 VNB VNB.t2 1409.71
R45 VNB.t2 VNB.t4 1423.95
R46 VNB.t4 VNB.t0 1423.95
R47 VNB.t0 VNB.t3 1423.95
R48 VNB.t3 VNB.t5 1196.12
R49 VNB.t5 VNB.t1 2677.02
R50 a_443_47.t0 a_443_47.t1 49.8467
R51 a_61_47.n0 a_61_47.t1 295.553
R52 a_61_47.n0 a_61_47.t2 32.3082
R53 a_61_47.t0 a_61_47.n0 32.3082
R54 a_143_297.t0 a_143_297.t1 68.9505
R55 a_61_297.n0 a_61_297.n1 292.5
R56 a_61_297.t0 a_61_297.n0 34.4755
R57 a_61_297.n0 a_61_297.t1 34.4755
R58 a_61_297.n1 a_61_297.t2 428.752
R59 a_61_297.n1 a_61_297.t3 383.769
R60 a_343_47.t1 a_343_47.n0 26.5955
R61 a_343_47.n0 a_343_47.t3 26.5955
R62 a_343_47.n0 a_343_47.n2 655.777
R63 a_343_47.n2 a_343_47.n3 182.119
R64 a_343_47.n3 a_343_47.t4 169.237
R65 a_343_47.n3 a_343_47.t5 241.536
R66 a_343_47.n2 a_343_47.n1 191.476
R67 a_343_47.n1 a_343_47.t0 32.3082
R68 a_343_47.n1 a_343_47.t2 32.3082
C0 VPB VPWR 0.1248f
C1 C A 0.05557f
C2 VGND A 0.02668f
C3 Y B 0.00113f
C4 VGND C 0.01426f
C5 VPWR A 0.02932f
C6 VPB B 0.06102f
C7 VPWR C 0.01425f
C8 VPB Y 0.01833f
C9 VPWR VGND 0.02939f
C10 B A 0.12935f
C11 Y A 0
C12 C B 0.04818f
C13 Y C 0
C14 VGND B 0.06332f
C15 VPB A 0.07265f
C16 VGND Y 0.04239f
C17 VPWR B 0.05224f
C18 VPB C 0.0278f
C19 VPWR Y 0.05941f
C20 VPB VGND 0.01251f
C21 VGND VNB 0.10646f
C22 Y VNB 0f
C23 VPWR VNB 0f
C24 C VNB 0.01857f
C25 B VNB 0f
C26 A VNB 0f
C27 VPB VNB 0.57622f
C28 a_343_47.t1 VNB 0.04923f
C29 a_343_47.n0 VNB 0.04385f
C30 a_343_47.n1 VNB 0.07453f
C31 a_343_47.t0 VNB 0.03924f
C32 a_343_47.t2 VNB 0.03797f
C33 a_343_47.n2 VNB 0.16432f
C34 a_343_47.n3 VNB 0.04817f
C35 a_343_47.t3 VNB 0.05082f
C36 a_61_297.t0 VNB 0.0521f
C37 a_61_297.n0 VNB 0.04224f
C38 a_61_297.t2 VNB 0.10616f
C39 a_61_297.t3 VNB 0.10021f
C40 a_61_297.n1 VNB 0.17542f
C41 a_61_297.t1 VNB 0.05034f
C42 a_143_297.t0 VNB 0.04675f
C43 a_143_297.t1 VNB 0.04834f
C44 a_61_47.t0 VNB 0.03653f
C45 a_61_47.n0 VNB 0.09824f
C46 a_61_47.t1 VNB 0.10951f
C47 a_61_47.t2 VNB 0.03641f
C48 a_443_47.t0 VNB 0.031f
C49 a_443_47.t1 VNB 0.03215f
C50 VPB.t0 VNB 0.04386f
C51 VPB.t1 VNB 0.11405f
C52 VPB.t2 VNB 0.04364f
C53 VPB.t3 VNB 0.04036f
C54 VPB.t4 VNB 0.04386f
C55 VPB.t5 VNB 0.05966f
C56 A.n0 VNB 0.05866f
C57 A.n1 VNB 0.07646f
C58 A.n2 VNB 0.05866f
C59 A.n3 VNB 0.07646f
C60 B.n0 VNB 0.06184f
C61 B.n1 VNB 0.07146f
C62 B.n2 VNB 0.06238f
C63 B.n3 VNB 0.11463f
C64 C.n0 VNB 0.06275f
C65 VPWR.n0 VNB 0.36523f
C66 VPWR.t1 VNB 0.04467f
C67 VPWR.t0 VNB 0.04483f
C68 VPWR.n1 VNB 0.02838f
C69 VPWR.t2 VNB 0.06408f
C70 Y.t1 VNB 0.03917f
C71 Y.n0 VNB 0.04349f
C72 Y.t0 VNB 0.06389f
C73 Y.n1 VNB 0.05942f
C74 VGND.n0 VNB 0.27298f
C75 VGND.t0 VNB 0.03685f
C76 VGND.t3 VNB 0.03082f
C77 VGND.n1 VNB 0.03086f
C78 VGND.t2 VNB 0.02761f
C79 VGND.t1 VNB 0.02876f
C80 VGND.n2 VNB 0.01451f
.ends
