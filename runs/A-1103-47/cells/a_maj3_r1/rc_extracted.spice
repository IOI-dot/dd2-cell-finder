* NGSPICE file created from a_maj3_r1.ext - technology: sky130A

.subckt a_maj3_r1 A B C VGND VNB VPB VPWR Y
X0 a_235_297.t0 B.t3 VPWR.t1 VPB.t2 sky130_fd_pr__pfet_01v8_hvt ad=0.3175 pd=1.635 as=0.135 ps=1.27 w=1 l=0.15 sa=0.68 sb=2.61
X1 VPWR.t0 C.t1 a_392_297.t0 VPB.t0 sky130_fd_pr__pfet_01v8_hvt ad=0.26 pd=2.52 as=0.2475 ps=1.495 w=1 l=0.15 sa=3.03 sb=0.26
X2 a_235_47.t1 B.t1 VGND.t1 VNB.t2 sky130_fd_pr__nfet_01v8 ad=0.20638 pd=1.285 as=0.08775 ps=0.92 w=0.65 l=0.15 sa=0.68 sb=2.61
X3 VPWR.t2 a_97_199.t5 Y.t0 VPB.t1 sky130_fd_pr__pfet_01v8_hvt ad=0.135 pd=1.27 as=0.26 ps=2.52 w=1 l=0.15 sa=0.26 sb=3.03
X4 a_235_47.t0 C.t0 a_97_199.t0 VNB.t0 sky130_fd_pr__nfet_01v8 ad=0.169 pd=1.82 as=0.16087 ps=1.145 w=0.65 l=0.15 sa=3.03 sb=0.26
X5 a_392_297.t3 A.t2 a_97_199.t2 VPB.t5 sky130_fd_pr__pfet_01v8_hvt ad=0.2475 pd=1.495 as=0.135 ps=1.27 w=1 l=0.15 sa=2.385 sb=0.905
X6 a_97_199.t1 B.t2 a_392_297.t1 VPB.t3 sky130_fd_pr__pfet_01v8_hvt ad=0.135 pd=1.27 as=0.175 ps=1.35 w=1 l=0.15 sa=1.965 sb=1.325
X7 a_392_297.t2 A.t3 a_235_297.t1 VPB.t4 sky130_fd_pr__pfet_01v8_hvt ad=0.175 pd=1.35 as=0.3175 ps=1.635 w=1 l=0.15 sa=1.465 sb=1.825
X8 a_492_47.t0 B.t0 VGND.t3 VNB.t3 sky130_fd_pr__nfet_01v8 ad=0.08775 pd=0.92 as=0.11375 ps=1 w=0.65 l=0.15 sa=1.965 sb=1.325
X9 VGND.t2 a_97_199.t4 Y.t1 VNB.t1 sky130_fd_pr__nfet_01v8 ad=0.08775 pd=0.92 as=0.169 ps=1.82 w=0.65 l=0.15 sa=0.26 sb=3.03
X10 VGND.t0 A.t1 a_235_47.t2 VNB.t4 sky130_fd_pr__nfet_01v8 ad=0.11375 pd=1 as=0.20638 ps=1.285 w=0.65 l=0.15 sa=1.465 sb=1.825
X11 a_97_199.t3 A.t0 a_492_47.t1 VNB.t5 sky130_fd_pr__nfet_01v8 ad=0.16087 pd=1.145 as=0.08775 ps=0.92 w=0.65 l=0.15 sa=2.385 sb=0.905
R0 VGND VGND.n0 0.297275
R1 VGND.n0 VGND.n1 216.767
R2 VGND.n0 VGND.n2 132.934
R3 VGND.n2 VGND.t2 24.9236
R4 VGND.n2 VGND.t1 24.9236
R5 VGND.n1 VGND.t0 32.3082
R6 VGND.n1 VGND.t3 32.3082
R7 VPWR VPWR.n0 0.198962
R8 VPWR.n0 VPWR.t0 270.921
R9 VPWR.n0 VPWR.n1 619.544
R10 VPWR.n1 VPWR.t2 26.5955
R11 VPWR.n1 VPWR.t1 26.5955
R12 Y.n1 Y.n0 73.9198
R13 Y Y.n1 3.29747
R14 Y.n1 Y.t0 228.772
R15 Y Y.n0 1.64144
R16 Y.n0 Y.t1 133.386
R17 C C.n0 158.4
R18 C.n0 C.t0 158.064
R19 C.n0 C.t1 230.363
R20 A.n1 A.n0 152
R21 A A.n1 6.4005
R22 A.n3 A.n1 25.192
R23 A A.n3 0.376971
R24 A.n3 A.n2 158.024
R25 A.n2 A.t0 158.064
R26 A.n2 A.t2 230.363
R27 A.n0 A.t1 169.237
R28 A.n0 A.t3 241.536
R29 B.n1 B.n0 152
R30 B B.n1 3.29747
R31 B.n3 B.n2 152
R32 B B.n3 3.29747
R33 B.n3 B.n1 95.4415
R34 B.n2 B.t0 169.237
R35 B.n2 B.t2 241.536
R36 B.n0 B.t1 158.064
R37 B.n0 B.t3 230.363
R38 VPB VPB.t1 316.668
R39 VPB.t1 VPB.t2 248.599
R40 VPB.t2 VPB.t4 464.642
R41 VPB.t4 VPB.t3 295.95
R42 VPB.t3 VPB.t5 248.599
R43 VPB.t5 VPB.t0 381.776
R44 VNB VNB.t1 1523.62
R45 VNB.t1 VNB.t2 1196.12
R46 VNB.t2 VNB.t4 2235.6
R47 VNB.t4 VNB.t3 1423.95
R48 VNB.t3 VNB.t5 1196.12
R49 VNB.t5 VNB.t0 1836.89
R50 a_492_47.t0 a_492_47.t1 49.8467
R51 a_235_47.t0 a_235_47.n0 396.519
R52 a_235_47.n0 a_235_47.t1 59.0774
R53 a_235_47.n0 a_235_47.t2 58.1543
R54 a_392_297.n0 a_392_297.n1 849.294
R55 a_392_297.n0 a_392_297.t3 48.2655
R56 a_392_297.t0 a_392_297.n0 49.2505
R57 a_392_297.n1 a_392_297.t2 34.4755
R58 a_392_297.n1 a_392_297.t1 34.4755
R59 a_235_297.t0 a_235_297.t1 125.096
R60 a_97_199.n0 a_97_199.n3 585
R61 a_97_199.t1 a_97_199.n0 26.5955
R62 a_97_199.n0 a_97_199.t2 26.5955
R63 a_97_199.n3 a_97_199.n1 216.469
R64 a_97_199.n3 a_97_199.n2 346.26
R65 a_97_199.n2 a_97_199.t4 169.237
R66 a_97_199.n2 a_97_199.t5 241.536
R67 a_97_199.n1 a_97_199.t3 45.2313
R68 a_97_199.n1 a_97_199.t0 46.1543
C0 C A 0.02721f
C1 VPWR B 0.02814f
C2 VPWR C 0.03665f
C3 VGND A 0.05295f
C4 VPB B 0.07461f
C5 VGND VPWR 0.02758f
C6 Y A 0.0012f
C7 VPB C 0.04342f
C8 Y VPWR 0.04745f
C9 VPB VGND 0.01117f
C10 VPB Y 0.02031f
C11 C B 0
C12 VPWR A 0.03042f
C13 VGND B 0.04064f
C14 VGND C 0.00965f
C15 Y B 0.0025f
C16 VPB A 0.07031f
C17 Y C 0
C18 VPB VPWR 0.13008f
C19 Y VGND 0.05784f
C20 A B 0.14806f
C21 VGND VNB 0.25032f
C22 VPWR VNB 0f
C23 Y VNB 0f
C24 C VNB 0.05643f
C25 A VNB 0f
C26 B VNB 0f
C27 VPB VNB 0.56891f
C28 a_97_199.t1 VNB 0.05371f
C29 a_97_199.n0 VNB 0.04541f
C30 a_97_199.t3 VNB 0.04887f
C31 a_97_199.t0 VNB 0.04496f
C32 a_97_199.n1 VNB 0.06829f
C33 a_97_199.n2 VNB 0.10253f
C34 a_97_199.n3 VNB 0.29166f
C35 a_97_199.t2 VNB 0.05331f
C36 a_235_297.t0 VNB 0.06297f
C37 a_235_297.t1 VNB 0.06337f
C38 a_392_297.t0 VNB 0.05151f
C39 a_392_297.n0 VNB 0.12667f
C40 a_392_297.t2 VNB 0.04996f
C41 a_392_297.t1 VNB 0.04996f
C42 a_392_297.n1 VNB 0.06209f
C43 a_392_297.t3 VNB 0.05714f
C44 a_235_47.t0 VNB 0.16967f
C45 a_235_47.n0 VNB 0.19231f
C46 a_235_47.t1 VNB 0.05438f
C47 a_235_47.t2 VNB 0.0542f
C48 a_492_47.t0 VNB 0.03081f
C49 a_492_47.t1 VNB 0.03048f
C50 VPB.t0 VNB 0.10942f
C51 VPB.t1 VNB 0.04345f
C52 VPB.t2 VNB 0.05482f
C53 VPB.t3 VNB 0.04186f
C54 VPB.t4 VNB 0.05846f
C55 VPB.t5 VNB 0.04845f
C56 B.n0 VNB 0.08562f
C57 B.n1 VNB 0.06366f
C58 B.n2 VNB 0.06207f
C59 B.n3 VNB 0.06366f
C60 A.n0 VNB 0.06207f
C61 A.n1 VNB 0.05968f
C62 A.n2 VNB 0.08616f
C63 A.n3 VNB 0.09582f
C64 C.n0 VNB 0.06881f
C65 Y.n0 VNB 0.02871f
C66 Y.t1 VNB 0.04384f
C67 Y.n1 VNB 0.07093f
C68 Y.t0 VNB 0.07179f
C69 VPWR.n0 VNB 0.39986f
C70 VPWR.t2 VNB 0.03623f
C71 VPWR.t1 VNB 0.04113f
C72 VPWR.n1 VNB 0.02187f
C73 VPWR.t0 VNB 0.06817f
C74 VGND.n0 VNB 0.24182f
C75 VGND.t0 VNB 0.03005f
C76 VGND.t3 VNB 0.03005f
C77 VGND.n1 VNB 0.01733f
C78 VGND.n2 VNB 0.01767f
C79 VGND.t2 VNB 0.02446f
C80 VGND.t1 VNB 0.02797f
.ends
