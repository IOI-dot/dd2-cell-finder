* NGSPICE file created from f_nest2.ext - technology: sky130A

.subckt f_nest2 A B C D VGND VNB VPB VPWR Y
X0 a_149_297# C a_349_297# VPB sky130_fd_pr__pfet_01v8_hvt ad=0.26 pd=2.52 as=0.135 ps=1.27 w=1 l=0.15 sa=1.68 sb=0.26
X1 a_249_47# B Y.t2 VNB sky130_fd_pr__nfet_01v8 ad=0.11375 pd=1 as=0.11375 ps=1 w=0.65 l=0.15 sa=0.76 sb=1.18
X2 a_349_297# D VPWR VPB sky130_fd_pr__pfet_01v8_hvt ad=0.135 pd=1.27 as=0.175 ps=1.35 w=1 l=0.15 sa=1.26 sb=0.68
X3 Y.t1 A VGND VNB sky130_fd_pr__nfet_01v8 ad=0.11375 pd=1 as=0.169 ps=1.82 w=0.65 l=0.15 sa=0.26 sb=1.68
X4 VPWR B a_149_297# VPB sky130_fd_pr__pfet_01v8_hvt ad=0.175 pd=1.35 as=0.175 ps=1.35 w=1 l=0.15 sa=0.76 sb=1.18
X5 a_249_47# C VGND VNB sky130_fd_pr__nfet_01v8 ad=0.169 pd=1.82 as=0.08775 ps=0.92 w=0.65 l=0.15 sa=1.68 sb=0.26
X6 a_149_297# A Y.t0 VPB sky130_fd_pr__pfet_01v8_hvt ad=0.175 pd=1.35 as=0.26 ps=2.52 w=1 l=0.15 sa=0.26 sb=1.68
X7 VGND D a_249_47# VNB sky130_fd_pr__nfet_01v8 ad=0.08775 pd=0.92 as=0.11375 ps=1 w=0.65 l=0.15 sa=1.26 sb=0.68
R0 Y.n0 Y 587.092
R1 Y.n1 Y.n0 290.423
R2 Y.n4 Y.n3 185
R3 Y.n3 Y.n2 185
R4 Y.n2 Y.n1 106.766
R5 Y.n3 Y.t1 32.3082
R6 Y.n3 Y.t2 32.3082
R7 Y.n0 Y.t0 26.5955
R8 Y Y.n5 20.4005
R9 Y.n5 Y.n4 12.8005
R10 Y.n5 Y.n2 12.8005
R11 Y.n1 Y 10.4328
R12 Y.n4 Y 6.4005
C0 a_349_297# a_249_47# 0.00133f
C1 VGND VPWR 0.03005f
C2 C a_249_47# 0.02741f
C3 VPWR A 0.01466f
C4 VPB a_149_297# 0.02478f
C5 Y a_249_47# 0.02361f
C6 D a_149_297# 0.02271f
C7 C a_349_297# 0
C8 B VPB 0.02917f
C9 C Y 0
C10 D B 0.03085f
C11 VGND VPB 0.01012f
C12 A VPB 0.03386f
C13 VPWR VPB 0.08134f
C14 VGND D 0.01669f
C15 D VPWR 0.01711f
C16 a_149_297# a_249_47# 0.00695f
C17 B a_249_47# 0.00605f
C18 a_349_297# a_149_297# 0.01661f
C19 C a_149_297# 0.02741f
C20 VGND a_249_47# 0.09829f
C21 VPWR a_249_47# 0.00357f
C22 D VPB 0.02804f
C23 Y a_149_297# 0.03938f
C24 VGND a_349_297# 0.00176f
C25 VGND C 0.01525f
C26 B Y 0.01309f
C27 VPWR a_349_297# 0.00927f
C28 C VPWR 0.01248f
C29 VGND Y 0.06623f
C30 Y A 0.0569f
C31 VPWR Y 0.04674f
C32 VPB a_249_47# 0.0021f
C33 D a_249_47# 0.02764f
C34 C VPB 0.03194f
C35 B a_149_297# 0.02766f
C36 D a_349_297# 0
C37 C D 0.03192f
C38 VGND a_149_297# 0.00516f
C39 Y VPB 0.02306f
C40 A a_149_297# 0.00792f
C41 VPWR a_149_297# 0.11377f
C42 D Y 0
C43 VGND B 0.01742f
C44 B A 0.03085f
C45 B VPWR 0.01627f
C46 VGND A 0.01745f
C47 VGND VNB 0.40677f
C48 VPWR VNB 0.31231f
C49 Y VNB 0.14056f
C50 VPB VNB 0.60476f
C51 a_249_47# VNB 0.06044f
C52 a_349_297# VNB 0.07293f
C53 a_149_297# VNB 0.07886f
C54 Y.t0 VNB 0.01361f
C55 Y.n0 VNB 0.03887f
C56 Y.n1 VNB 0.06751f
C57 Y.n2 VNB 0.03253f
C58 Y.t2 VNB 0.03996f
C59 Y.t1 VNB 0.05289f
C60 Y.n3 VNB 0.02294f
C61 Y.n4 VNB 0.00437f
C62 Y.n5 VNB 0.01817f
.ends
