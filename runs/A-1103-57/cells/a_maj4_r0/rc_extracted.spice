* NGSPICE file created from a_maj4_r0.ext - technology: sky130A

.subckt a_maj4_r0 A B C D VGND VNB VPB VPWR Y
X0 a_133_297.t3 B.t1 a_51_297.t4 VPB.t6 sky130_fd_pr__pfet_01v8_hvt ad=0.165 pd=1.33 as=0.26 ps=2.52 w=1 l=0.15 sa=0.26 sb=3.22
X1 a_51_297.t0 C.t1 a_229_47.t0 VNB.t1 sky130_fd_pr__nfet_01v8 ad=0.10725 pd=0.98 as=0.13325 ps=1.06 w=0.65 l=0.15 sa=1.3 sb=2.18
X2 a_133_47.t1 B.t0 VGND.t0 VNB.t6 sky130_fd_pr__nfet_01v8 ad=0.10725 pd=0.98 as=0.169 ps=1.82 w=0.65 l=0.15 sa=0.26 sb=3.22
X3 a_533_47.t0 C.t0 a_229_47.t1 VNB.t2 sky130_fd_pr__nfet_01v8 ad=0.10725 pd=0.98 as=0.10725 ps=0.98 w=0.65 l=0.15 sa=2.26 sb=1.22
X4 a_229_47.t2 D.t1 a_51_297.t2 VNB.t3 sky130_fd_pr__nfet_01v8 ad=0.10725 pd=0.98 as=0.10725 ps=0.98 w=0.65 l=0.15 sa=1.78 sb=1.7
X5 Y.t0 a_51_297.t6 VPWR.t1 VPB.t0 sky130_fd_pr__pfet_01v8_hvt ad=0.26 pd=2.52 as=0.165 ps=1.33 w=1 l=0.15 sa=3.22 sb=0.26
X6 VPWR.t2 D.t2 a_133_297.t1 VPB.t4 sky130_fd_pr__pfet_01v8_hvt ad=0.165 pd=1.33 as=0.165 ps=1.33 w=1 l=0.15 sa=2.74 sb=0.74
X7 Y.t1 a_51_297.t5 VGND.t1 VNB.t0 sky130_fd_pr__nfet_01v8 ad=0.169 pd=1.82 as=0.10725 ps=0.98 w=0.65 l=0.15 sa=3.22 sb=0.26
X8 a_51_297.t3 A.t1 a_133_297.t2 VPB.t5 sky130_fd_pr__pfet_01v8_hvt ad=0.205 pd=1.41 as=0.165 ps=1.33 w=1 l=0.15 sa=0.74 sb=2.74
X9 VGND.t2 D.t0 a_533_47.t1 VNB.t4 sky130_fd_pr__nfet_01v8 ad=0.10725 pd=0.98 as=0.10725 ps=0.98 w=0.65 l=0.15 sa=2.74 sb=0.74
X10 a_341_297.t0 C.t3 a_51_297.t1 VPB.t1 sky130_fd_pr__pfet_01v8_hvt ad=0.165 pd=1.33 as=0.205 ps=1.41 w=1 l=0.15 sa=1.3 sb=2.18
X11 a_133_297.t0 C.t2 VPWR.t0 VPB.t2 sky130_fd_pr__pfet_01v8_hvt ad=0.165 pd=1.33 as=0.165 ps=1.33 w=1 l=0.15 sa=2.26 sb=1.22
X12 a_229_47.t3 A.t0 a_133_47.t0 VNB.t5 sky130_fd_pr__nfet_01v8 ad=0.13325 pd=1.06 as=0.10725 ps=0.98 w=0.65 l=0.15 sa=0.74 sb=2.74
X13 VPWR.t3 D.t3 a_341_297.t1 VPB.t3 sky130_fd_pr__pfet_01v8_hvt ad=0.165 pd=1.33 as=0.165 ps=1.33 w=1 l=0.15 sa=1.78 sb=1.7
R0 VGND VGND.n0 0.0818322
R1 VGND.n0 VGND.n1 219.478
R2 VGND.n0 VGND.t0 302.618
R3 VGND.n1 VGND.t2 30.462
R4 VGND.n1 VGND.t1 30.462
R5 Y Y.n0 6.4005
R6 Y.n1 Y.t0 227.356
R7 Y Y.n1 6.4005
R8 Y.n1 Y.n0 85.0829
R9 Y.n0 Y.t1 134.204
R10 VPWR VPWR.n0 0.915021
R11 VPWR.n0 VPWR.n2 242.311
R12 VPWR.n2 VPWR.t2 32.5055
R13 VPWR.n2 VPWR.t1 32.5055
R14 VPWR.n0 VPWR.n1 619.008
R15 VPWR.n1 VPWR.t3 32.5055
R16 VPWR.n1 VPWR.t0 32.5055
R17 D.n1 D.n0 152
R18 D D.n1 3.29747
R19 D.n2 D.n1 19.1222
R20 D.n2 D.n3 152
R21 D D.n2 3.29747
R22 D.n3 D.t0 169.237
R23 D.n3 D.t2 241.536
R24 D.n0 D.t1 169.237
R25 D.n0 D.t3 241.536
R26 C C.n4 6.8005
R27 C.n1 C.n0 152
R28 C C.n4 3.30373
R29 C.n4 C.n1 0.206952
R30 C.n3 C.n2 152
R31 C C.n3 6.4005
R32 C.n1 C.n3 106.579
R33 C.n2 C.t0 169.237
R34 C.n2 C.t2 241.536
R35 C.n0 C.t1 169.237
R36 C.n0 C.t3 241.536
R37 A A.n0 155.298
R38 A.n0 A.t0 169.237
R39 A.n0 A.t1 241.536
R40 B B.n0 155.298
R41 B.n0 B.t0 169.237
R42 B.n0 B.t1 241.536
R43 VPB VPB.t6 263.397
R44 VPB.t6 VPB.t5 284.113
R45 VPB.t5 VPB.t1 331.464
R46 VPB.t1 VPB.t3 284.113
R47 VPB.t3 VPB.t2 284.113
R48 VPB.t2 VPB.t4 284.113
R49 VPB.t4 VPB.t0 284.113
R50 VNB VNB.t6 1267.31
R51 VNB.t6 VNB.t5 1366.99
R52 VNB.t5 VNB.t1 1594.82
R53 VNB.t1 VNB.t3 1366.99
R54 VNB.t3 VNB.t2 1366.99
R55 VNB.t2 VNB.t4 1366.99
R56 VNB.t4 VNB.t0 1366.99
R57 a_533_47.t0 a_533_47.t1 60.9236
R58 a_229_47.n0 a_229_47.t3 37.8467
R59 a_229_47.t0 a_229_47.n0 37.8467
R60 a_229_47.n0 a_229_47.n1 445.295
R61 a_229_47.n1 a_229_47.t2 30.462
R62 a_229_47.n1 a_229_47.t1 30.462
R63 a_133_47.t0 a_133_47.t1 60.9236
R64 a_341_297.t0 a_341_297.t1 65.0105
R65 a_133_297.t0 a_133_297.n0 32.5055
R66 a_133_297.n0 a_133_297.t1 32.5055
R67 a_133_297.n0 a_133_297.n1 1037.74
R68 a_133_297.n1 a_133_297.t3 32.5055
R69 a_133_297.n1 a_133_297.t2 32.5055
R70 a_51_297.n0 a_51_297.n4 585
R71 a_51_297.n0 a_51_297.t3 40.3855
R72 a_51_297.t1 a_51_297.n0 40.3855
R73 a_51_297.n4 a_51_297.t4 289.384
R74 a_51_297.n2 a_51_297.n1 185
R75 a_51_297.n4 a_51_297.n2 95.624
R76 a_51_297.n2 a_51_297.n3 183.673
R77 a_51_297.n3 a_51_297.t5 169.237
R78 a_51_297.n3 a_51_297.t6 241.536
R79 a_51_297.n1 a_51_297.t0 30.462
R80 a_51_297.n1 a_51_297.t2 30.462
C0 D VPB 0.05573f
C1 VGND Y 0.0425f
C2 VPB VGND 0.01277f
C3 A Y 0
C4 D VGND 0.02539f
C5 C VPWR 0.03902f
C6 A VPB 0.02823f
C7 B VPWR 0.01186f
C8 D A 0
C9 A VGND 0.01799f
C10 VPWR Y 0.06848f
C11 C Y 0.00268f
C12 B Y 0
C13 VPB VPWR 0.11606f
C14 VPB C 0.06303f
C15 D VPWR 0.06478f
C16 B VPB 0.03123f
C17 D C 0.16342f
C18 D B 0
C19 VGND VPWR 0.02726f
C20 C VGND 0.02488f
C21 B VGND 0.02229f
C22 A VPWR 0.01024f
C23 A C 0.01678f
C24 A B 0.03636f
C25 VPB Y 0.01786f
C26 D Y 0.00269f
C27 VGND VNB 0.11817f
C28 Y VNB 0f
C29 VPWR VNB 0.1523f
C30 D VNB 0f
C31 C VNB 0f
C32 A VNB 0.0262f
C33 B VNB 0.06788f
C34 VPB VNB 0.58057f
C35 a_51_297.t1 VNB 0.05885f
C36 a_51_297.n0 VNB 0.05805f
C37 a_51_297.t0 VNB 0.03674f
C38 a_51_297.t2 VNB 0.03716f
C39 a_51_297.n1 VNB 0.03037f
C40 a_51_297.n2 VNB 0.19035f
C41 a_51_297.n3 VNB 0.05892f
C42 a_51_297.n4 VNB 0.14068f
C43 a_51_297.t4 VNB 0.11287f
C44 a_51_297.t3 VNB 0.05561f
C45 a_133_297.t0 VNB 0.05428f
C46 a_133_297.n0 VNB 0.16303f
C47 a_133_297.t3 VNB 0.04601f
C48 a_133_297.t2 VNB 0.05104f
C49 a_133_297.n1 VNB 0.10867f
C50 a_133_297.t1 VNB 0.05486f
C51 a_341_297.t0 VNB 0.04525f
C52 a_341_297.t1 VNB 0.04583f
C53 a_133_47.t0 VNB 0.03008f
C54 a_133_47.t1 VNB 0.02644f
C55 a_229_47.t0 VNB 0.03976f
C56 a_229_47.n0 VNB 0.06882f
C57 a_229_47.t2 VNB 0.03663f
C58 a_229_47.t1 VNB 0.0362f
C59 a_229_47.n1 VNB 0.06234f
C60 a_229_47.t3 VNB 0.03741f
C61 a_533_47.t0 VNB 0.03378f
C62 a_533_47.t1 VNB 0.0342f
C63 VPB.t0 VNB 0.08687f
C64 VPB.t1 VNB 0.04428f
C65 VPB.t2 VNB 0.04088f
C66 VPB.t3 VNB 0.04088f
C67 VPB.t4 VNB 0.04088f
C68 VPB.t5 VNB 0.04428f
C69 VPB.t6 VNB 0.03939f
C70 B.n0 VNB 0.0434f
C71 A.n0 VNB 0.05353f
C72 C.n0 VNB 0.0597f
C73 C.n1 VNB 0.06674f
C74 C.n2 VNB 0.0597f
C75 C.n3 VNB 0.05559f
C76 C.n4 VNB 0.01311f
C77 D.n0 VNB 0.06087f
C78 D.n1 VNB 0.07397f
C79 D.n2 VNB 0.07397f
C80 D.n3 VNB 0.06087f
C81 VPWR.n0 VNB 0.24593f
C82 VPWR.t3 VNB 0.04395f
C83 VPWR.t0 VNB 0.04337f
C84 VPWR.n1 VNB 0.02791f
C85 VPWR.n2 VNB 0.0335f
C86 VPWR.t2 VNB 0.04395f
C87 VPWR.t1 VNB 0.03518f
C88 Y.t1 VNB 0.04351f
C89 Y.n0 VNB 0.05441f
C90 Y.t0 VNB 0.07202f
C91 Y.n1 VNB 0.07382f
C92 VGND.n0 VNB 0.32623f
C93 VGND.t2 VNB 0.02874f
C94 VGND.t1 VNB 0.0224f
C95 VGND.n1 VNB 0.01596f
C96 VGND.t0 VNB 0.0361f
.ends
