* NGSPICE file created from a_nand3_r3.ext - technology: sky130A

.subckt a_nand3_r3 A B C VGND VNB VPB VPWR Y
X0 a_147_47# A Y VNB sky130_fd_pr__nfet_01v8 ad=0.169 pd=1.82 as=0.169 ps=1.82 w=0.65 l=0.15 sa=0.26 sb=0.26
X1 Y A VPWR VPB sky130_fd_pr__pfet_01v8_hvt ad=0.395 pd=1.79 as=0.26 ps=2.52 w=1 l=0.15 sa=0.26 sb=1.7
X2 Y B VPWR VPB sky130_fd_pr__pfet_01v8_hvt ad=0.26 pd=2.52 as=0.175 ps=1.35 w=1 l=0.15 sa=1.7 sb=0.26
X3 a_147_47# B a_335_47# VNB sky130_fd_pr__nfet_01v8 ad=0.169 pd=1.82 as=0.11375 ps=1 w=0.65 l=0.15 sa=0.76 sb=0.26
X4 VPWR C Y VPB sky130_fd_pr__pfet_01v8_hvt ad=0.175 pd=1.35 as=0.395 ps=1.79 w=1 l=0.15 sa=1.2 sb=0.76
X5 a_335_47# C VGND VNB sky130_fd_pr__nfet_01v8 ad=0.11375 pd=1 as=0.169 ps=1.82 w=0.65 l=0.15 sa=0.26 sb=0.76
C0 VPB a_147_47# 0.00325f
C1 C VPWR 0.01684f
C2 VPWR A 0.01856f
C3 Y VPB 0.03788f
C4 VPWR B 0.01603f
C5 VGND VPB 0.01096f
C6 C A 0.01232f
C7 VPWR VPB 0.08879f
C8 C B 0.03085f
C9 Y a_147_47# 0.04126f
C10 VGND a_147_47# 0.09516f
C11 C VPB 0.03358f
C12 VPB A 0.03786f
C13 VGND Y 0.05038f
C14 VPWR a_147_47# 0.00399f
C15 VPB B 0.03354f
C16 a_335_47# a_147_47# 0.01316f
C17 Y VPWR 0.18088f
C18 VGND VPWR 0.03076f
C19 a_335_47# VGND 0.01028f
C20 C a_147_47# 0.02473f
C21 A a_147_47# 0.00515f
C22 C Y 0.02604f
C23 B a_147_47# 0.02617f
C24 C VGND 0.0172f
C25 a_335_47# VPWR 0.0011f
C26 Y A 0.05101f
C27 VGND A 0.01595f
C28 Y B 0.02537f
C29 VGND B 0.01301f
C30 VGND VNB 0.35437f
C31 Y VNB 0.25305f
C32 VPWR VNB 0.37426f
C33 VPB VNB 0.60476f
C34 a_147_47# VNB 0.09187f
.ends
