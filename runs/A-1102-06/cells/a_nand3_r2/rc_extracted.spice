* NGSPICE file created from a_nand3_r2.ext - technology: sky130A

.subckt a_nand3_r2 A B C VGND VNB VPB VPWR Y
X0 a_297_47# A Y VNB sky130_fd_pr__nfet_01v8 ad=0.08775 pd=0.92 as=0.169 ps=1.82 w=0.65 l=0.15 sa=0.26 sb=0.68
X1 Y B VPWR VPB sky130_fd_pr__pfet_01v8_hvt ad=0.26 pd=2.52 as=0.135 ps=1.27 w=1 l=0.15 sa=1.62 sb=0.26
X2 a_109_47# B a_297_47# VNB sky130_fd_pr__nfet_01v8 ad=0.169 pd=1.82 as=0.08775 ps=0.92 w=0.65 l=0.15 sa=0.68 sb=0.26
X3 VPWR A Y VPB sky130_fd_pr__pfet_01v8_hvt ad=0.135 pd=1.27 as=0.395 ps=1.79 w=1 l=0.15 sa=1.2 sb=0.68
X4 Y C VPWR VPB sky130_fd_pr__pfet_01v8_hvt ad=0.395 pd=1.79 as=0.26 ps=2.52 w=1 l=0.15 sa=0.26 sb=1.62
X5 a_109_47# C VGND VNB sky130_fd_pr__nfet_01v8 ad=0.169 pd=1.82 as=0.169 ps=1.82 w=0.65 l=0.15 sa=0.26 sb=0.26
C0 VGND VPB 0.00723f
C1 a_297_47# B 0
C2 A C 0.00943f
C3 VPWR VPB 0.07706f
C4 A B 0.03192f
C5 Y a_109_47# 0.03789f
C6 VGND a_109_47# 0.11748f
C7 A VPB 0.03166f
C8 VPB C 0.03784f
C9 VGND Y 0.02106f
C10 VPB B 0.0301f
C11 VPWR a_109_47# 0.00459f
C12 a_297_47# a_109_47# 0.00899f
C13 Y VPWR 0.15123f
C14 VGND VPWR 0.0274f
C15 a_297_47# Y 0.00306f
C16 a_297_47# VGND 0.00343f
C17 A a_109_47# 0.0123f
C18 C a_109_47# 0.00448f
C19 A Y 0.05079f
C20 B a_109_47# 0.02152f
C21 A VGND 0.01049f
C22 a_297_47# VPWR 0
C23 Y C 0.01914f
C24 VGND C 0.02865f
C25 Y B 0.03137f
C26 VGND B 0.00949f
C27 VPB a_109_47# 0.00335f
C28 A VPWR 0.01765f
C29 VPWR C 0.03277f
C30 a_297_47# A 0
C31 Y VPB 0.01993f
C32 VPWR B 0.01534f
C33 VGND VNB 0.32791f
C34 Y VNB 0.20086f
C35 VPWR VNB 0.37795f
C36 VPB VNB 0.51617f
C37 a_297_47# VNB 0.03279f
C38 a_109_47# VNB 0.03439f
.ends
