* NGSPICE file created from a_nand3_r1.ext - technology: sky130A

.subckt a_nand3_r1 A B C VGND VNB VPB VPWR Y
X0 Y C VPWR VPB sky130_fd_pr__pfet_01v8_hvt ad=0.26 pd=2.52 as=0.135 ps=1.27 w=1 l=0.15 sa=1.16 sb=0.26
X1 VPWR B Y VPB sky130_fd_pr__pfet_01v8_hvt ad=0.135 pd=1.27 as=0.165 ps=1.33 w=1 l=0.15 sa=0.74 sb=0.68
X2 a_205_47# B a_109_47# VNB sky130_fd_pr__nfet_01v8 ad=0.08775 pd=0.92 as=0.10725 ps=0.98 w=0.65 l=0.15 sa=0.74 sb=0.68
X3 VGND C a_205_47# VNB sky130_fd_pr__nfet_01v8 ad=0.169 pd=1.82 as=0.08775 ps=0.92 w=0.65 l=0.15 sa=1.16 sb=0.26
X4 Y A VPWR VPB sky130_fd_pr__pfet_01v8_hvt ad=0.165 pd=1.33 as=0.26 ps=2.52 w=1 l=0.15 sa=0.26 sb=1.16
X5 a_109_47# A Y VNB sky130_fd_pr__nfet_01v8 ad=0.10725 pd=0.98 as=0.169 ps=1.82 w=0.65 l=0.15 sa=0.26 sb=1.16
C0 Y VPWR 0.15312f
C1 VGND VPWR 0.02109f
C2 a_205_47# Y 0.01112f
C3 a_205_47# VGND 0.00217f
C4 B a_109_47# 0
C5 B Y 0.06349f
C6 B VGND 0.01021f
C7 a_205_47# VPWR 0
C8 Y A 0.02934f
C9 VGND A 0.00983f
C10 Y C 0.06021f
C11 VGND C 0.02404f
C12 B VPWR 0.01688f
C13 VPWR A 0.02993f
C14 Y VPB 0.01915f
C15 VPWR C 0.01462f
C16 VGND VPB 0.00584f
C17 B A 0.03636f
C18 VPWR VPB 0.0588f
C19 B C 0.02548f
C20 Y a_109_47# 0.01612f
C21 VGND a_109_47# 0.00368f
C22 B VPB 0.0261f
C23 VPB A 0.0303f
C24 VGND Y 0.10255f
C25 VPWR a_109_47# 0.00114f
C26 VPB C 0.03716f
C27 VGND VNB 0.26454f
C28 Y VNB 0.22864f
C29 VPWR VNB 0.37616f
C30 VPB VNB 0.42757f
.ends
