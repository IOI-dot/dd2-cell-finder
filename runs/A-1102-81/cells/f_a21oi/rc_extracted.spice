* NGSPICE file created from f_a21oi.ext - technology: sky130A

.subckt f_a21oi A B C VGND VNB VPB VPWR Y
X0 Y.t1 C.t1 a_27_297.t1 VPB.t1 sky130_fd_pr__pfet_01v8_hvt ad=0.26 pd=2.52 as=0.135 ps=1.27 w=1 l=0.15 sa=1.16 sb=0.26
X1 a_27_297.t0 A.t1 VPWR.t1 VPB.t0 sky130_fd_pr__pfet_01v8_hvt ad=0.135 pd=1.27 as=0.165 ps=1.33 w=1 l=0.15 sa=0.74 sb=0.68
X2 Y.t0 A.t0 a_109_47.t0 VNB.t0 sky130_fd_pr__nfet_01v8 ad=0.08775 pd=0.92 as=0.10725 ps=0.98 w=0.65 l=0.15 sa=0.74 sb=0.68
X3 VGND.t1 C.t0 Y.t2 VNB.t1 sky130_fd_pr__nfet_01v8 ad=0.169 pd=1.82 as=0.08775 ps=0.92 w=0.65 l=0.15 sa=1.16 sb=0.26
X4 VPWR.t0 B.t1 a_27_297.t2 VPB.t2 sky130_fd_pr__pfet_01v8_hvt ad=0.165 pd=1.33 as=0.26 ps=2.52 w=1 l=0.15 sa=0.26 sb=1.16
X5 a_109_47.t1 B.t0 VGND.t0 VNB.t2 sky130_fd_pr__nfet_01v8 ad=0.10725 pd=0.98 as=0.169 ps=1.82 w=0.65 l=0.15 sa=0.26 sb=1.16
R0 VGND VGND.n0 0.136711
R1 VGND.n0 VGND.t1 299.445
R2 VGND.n0 VGND.t0 299.149
R3 Y.n1 Y.n2 89.3175
R4 Y Y.n1 9.66497
R5 Y.n0 Y.n1 118.825
R6 Y Y.n0 9.49822
R7 Y.n0 Y.t1 315.964
R8 Y.n2 Y.t0 24.9236
R9 Y.n2 Y.t2 24.9236
R10 VPWR VPWR.n0 614.823
R11 VPWR.n0 VPWR.t0 32.5055
R12 VPWR.n0 VPWR.t1 32.5055
R13 C C.n0 155.298
R14 C.n0 C.t0 158.064
R15 C.n0 C.t1 230.363
R16 A A.n0 155.298
R17 A.n0 A.t0 169.237
R18 A.n0 A.t1 241.536
R19 B B.n0 155.298
R20 B.n0 B.t0 169.237
R21 B.n0 B.t1 241.536
R22 VPB VPB.t2 192.369
R23 VPB.t2 VPB.t0 284.113
R24 VPB.t0 VPB.t1 248.599
R25 VNB VNB.t2 925.567
R26 VNB.t2 VNB.t0 1366.99
R27 VNB.t0 VNB.t1 1196.12
R28 a_109_47.t0 a_109_47.t1 60.9236
R29 a_27_297.t0 a_27_297.n0 26.5955
R30 a_27_297.n0 a_27_297.t1 26.5955
R31 a_27_297.n0 a_27_297.t2 573.249
C0 VGND Y 0.0516f
C1 B A 0.03636f
C2 B VGND 0.02261f
C3 C VPB 0.03719f
C4 VPWR VPB 0.04906f
C5 VGND A 0.01738f
C6 Y VPB 0.01482f
C7 VPWR C 0.01344f
C8 C Y 0.05733f
C9 VPWR Y 0.02718f
C10 B VPB 0.0302f
C11 B VPWR 0.01461f
C12 B Y 0.00449f
C13 A VPB 0.0261f
C14 VGND VPB 0.00769f
C15 C A 0.02548f
C16 VPWR A 0.01526f
C17 VGND C 0.02467f
C18 VPWR VGND 0.02247f
C19 A Y 0.02816f
C20 VGND VNB 0.20905f
C21 Y VNB 0f
C22 VPWR VNB 0.30859f
C23 C VNB 0.06356f
C24 A VNB 0.02115f
C25 B VNB 0.06894f
C26 VPB VNB 0.33012f
C27 a_27_297.t0 VNB 0.04156f
C28 a_27_297.n0 VNB 0.07928f
C29 a_27_297.t2 VNB 0.1397f
C30 a_27_297.t1 VNB 0.0376f
C31 a_109_47.t0 VNB 0.03089f
C32 a_109_47.t1 VNB 0.0265f
C33 VPB.t0 VNB 0.0358f
C34 VPB.t1 VNB 0.06921f
C35 VPB.t2 VNB 0.03202f
C36 B.n0 VNB 0.04334f
C37 A.n0 VNB 0.05558f
C38 C.n0 VNB 0.0664f
C39 VPWR.t0 VNB 0.03448f
C40 VPWR.t1 VNB 0.04056f
C41 VPWR.n0 VNB 0.02661f
C42 Y.n0 VNB 0.04192f
C43 Y.n1 VNB 0.05555f
C44 Y.n2 VNB 0.02138f
C45 Y.t0 VNB 0.03064f
C46 Y.t2 VNB 0.02774f
C47 Y.t1 VNB 0.08311f
C48 VGND.n0 VNB 0.07479f
C49 VGND.t1 VNB 0.03317f
C50 VGND.t0 VNB 0.03161f
.ends
