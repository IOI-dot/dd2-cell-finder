* NGSPICE file created from a_and2_r0.ext - technology: sky130A

.subckt a_and2_r0 A B VGND VNB VPB VPWR Y
X0 a_63_47# A VPWR VPB sky130_fd_pr__pfet_01v8_hvt ad=0.175 pd=1.35 as=0.26 ps=2.52 w=1 l=0.15 sa=0.26 sb=1.26
X1 VGND B a_145_47# VNB sky130_fd_pr__nfet_01v8 ad=0.11375 pd=1 as=0.11375 ps=1 w=0.65 l=0.15 sa=0.76 sb=0.76
X2 Y a_63_47# VPWR VPB sky130_fd_pr__pfet_01v8_hvt ad=0.26 pd=2.52 as=0.175 ps=1.35 w=1 l=0.15 sa=1.26 sb=0.26
X3 a_145_47# A a_63_47# VNB sky130_fd_pr__nfet_01v8 ad=0.11375 pd=1 as=0.169 ps=1.82 w=0.65 l=0.15 sa=0.26 sb=1.26
X4 VPWR B a_63_47# VPB sky130_fd_pr__pfet_01v8_hvt ad=0.175 pd=1.35 as=0.175 ps=1.35 w=1 l=0.15 sa=0.76 sb=0.76
X5 Y a_63_47# VGND VNB sky130_fd_pr__nfet_01v8 ad=0.169 pd=1.82 as=0.11375 ps=1 w=0.65 l=0.15 sa=1.26 sb=0.26
C0 VPB a_63_47# 0.04361f
C1 VGND VPWR 0.02708f
C2 VPWR Y 0.04338f
C3 B a_63_47# 0.08866f
C4 A a_63_47# 0.03705f
C5 VPB B 0.02894f
C6 a_145_47# VGND 0.01019f
C7 a_145_47# Y 0
C8 VPB A 0.03484f
C9 VGND a_63_47# 0.08837f
C10 Y a_63_47# 0.06794f
C11 VPB VGND 0.01088f
C12 A B 0.03085f
C13 VPB Y 0.01926f
C14 a_145_47# VPWR 0.0011f
C15 VGND B 0.0163f
C16 VPWR a_63_47# 0.13156f
C17 Y B 0.00102f
C18 A VGND 0.01326f
C19 A Y 0
C20 VPB VPWR 0.08707f
C21 a_145_47# a_63_47# 0.01222f
C22 VGND Y 0.04307f
C23 VPWR B 0.01712f
C24 A VPWR 0.03242f
C25 VGND VNB 0.33316f
C26 Y VNB 0.17565f
C27 VPWR VNB 0.40985f
C28 VPB VNB 0.51617f
C29 a_145_47# VNB 0.02845f
.ends
