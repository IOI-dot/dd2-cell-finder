* NGSPICE file created from f_nor3.ext - technology: sky130A

.subckt f_nor3 A B C VGND VNB VPB VPWR Y
X0 a_145_297# C VPWR VPB sky130_fd_pr__pfet_01v8_hvt ad=0.175 pd=1.35 as=0.26 ps=2.52 w=1 l=0.15 sa=0.26 sb=1.26
X1 VGND B Y VNB sky130_fd_pr__nfet_01v8 ad=0.11375 pd=1 as=0.11375 ps=1 w=0.65 l=0.15 sa=0.76 sb=0.76
X2 Y A a_245_297# VPB sky130_fd_pr__pfet_01v8_hvt ad=0.26 pd=2.52 as=0.175 ps=1.35 w=1 l=0.15 sa=1.26 sb=0.26
X3 Y C VGND VNB sky130_fd_pr__nfet_01v8 ad=0.11375 pd=1 as=0.169 ps=1.82 w=0.65 l=0.15 sa=0.26 sb=1.26
X4 a_245_297# B a_145_297# VPB sky130_fd_pr__pfet_01v8_hvt ad=0.175 pd=1.35 as=0.175 ps=1.35 w=1 l=0.15 sa=0.76 sb=0.76
X5 Y A VGND VNB sky130_fd_pr__nfet_01v8 ad=0.169 pd=1.82 as=0.11375 ps=1 w=0.65 l=0.15 sa=1.26 sb=0.26
C0 VPWR a_145_297# 0.02219f
C1 VPB A 0.03531f
C2 Y VPWR 0.0497f
C3 VGND VPWR 0.02832f
C4 a_245_297# Y 0.01131f
C5 a_245_297# VGND 0.00276f
C6 B a_145_297# 0.00288f
C7 C a_145_297# 0
C8 B Y 0.03325f
C9 B VGND 0.01725f
C10 a_245_297# VPWR 0.01863f
C11 Y C 0.00854f
C12 VGND C 0.03072f
C13 Y A 0.0517f
C14 VGND A 0.01548f
C15 B VPWR 0.02136f
C16 VPWR C 0.0322f
C17 a_245_297# B 0
C18 Y VPB 0.02176f
C19 VPWR A 0.01683f
C20 VGND VPB 0.0118f
C21 a_245_297# A 0.00288f
C22 B C 0.03085f
C23 VPWR VPB 0.09501f
C24 B A 0.03085f
C25 Y a_145_297# 0.00779f
C26 VGND a_145_297# 0.00276f
C27 B VPB 0.03109f
C28 VPB C 0.03487f
C29 VGND Y 0.12936f
C30 VGND VNB 0.36238f
C31 Y VNB 0.17298f
C32 VPWR VNB 0.32372f
C33 VPB VNB 0.51617f
C34 a_245_297# VNB 0.04148f
C35 a_145_297# VNB 0.04477f
.ends
