* NGSPICE file created from f_xor3.ext - technology: sky130A

.subckt f_xor3 A B C VGND VNB VPB VPWR Y
X0 VGND.t5 a_581_199# a_535_47.t1 VNB.t1 sky130_fd_pr__nfet_01v8 ad=0.25675 pd=1.44 as=0.11375 ps=1 w=0.65 l=0.15 sa=2.7 sb=3.86
X1 a_247_297# A.t3 a_147_297.t0 VPB.t4 sky130_fd_pr__pfet_01v8_hvt ad=0.26 pd=2.52 as=0.175 ps=1.35 w=1 l=0.15 sa=0.76 sb=0.26
X2 a_353_297.t1 A.t2 VPWR.t0 VPB.t5 sky130_fd_pr__pfet_01v8_hvt ad=0.175 pd=1.35 as=0.175 ps=1.35 w=1 l=0.15 sa=0.76 sb=0.76
X3 VGND.t3 A.t1 a_147_47.t0 VNB.t4 sky130_fd_pr__nfet_01v8 ad=0.25675 pd=1.44 as=0.11375 ps=1 w=0.65 l=0.15 sa=0.76 sb=5.8
X4 VGND.t7 a_535_47.t4 a_823_47.t1 VNB.t9 sky130_fd_pr__nfet_01v8 ad=0.25675 pd=1.44 as=0.11375 ps=1 w=0.65 l=0.15 sa=4.14 sb=2.42
X5 a_535_47.t2 A.t0 a_435_47.t0 VNB.t5 sky130_fd_pr__nfet_01v8 ad=0.11375 pd=1 as=0.11375 ps=1 w=0.65 l=0.15 sa=2.2 sb=4.36
X6 Y.t0 a_1325_21# a_1029_297.t0 VPB.t0 sky130_fd_pr__pfet_01v8_hvt ad=0.26 pd=2.52 as=0.175 ps=1.35 w=1 l=0.15 sa=1.48 sb=0.26
X7 a_147_47.t1 B.t1 VGND.t0 VNB.t6 sky130_fd_pr__nfet_01v8 ad=0.11375 pd=1 as=0.169 ps=1.82 w=0.65 l=0.15 sa=0.26 sb=6.3
X8 a_147_297.t1 B.t3 VPWR.t2 VPB.t6 sky130_fd_pr__pfet_01v8_hvt ad=0.175 pd=1.35 as=0.26 ps=2.52 w=1 l=0.15 sa=0.26 sb=0.76
X9 VPWR.t1 B.t2 a_353_297.t2 VPB.t7 sky130_fd_pr__pfet_01v8_hvt ad=0.175 pd=1.35 as=0.26 ps=2.52 w=1 l=0.15 sa=0.26 sb=1.26
X10 a_823_47.t0 C.t1 VGND.t1 VNB.t2 sky130_fd_pr__nfet_01v8 ad=0.11375 pd=1 as=0.25675 ps=1.44 w=0.65 l=0.15 sa=3.64 sb=2.92
X11 a_1111_47.t0 C.t0 VGND.t2 VNB.t3 sky130_fd_pr__nfet_01v8 ad=0.18525 pd=1.22 as=0.25675 ps=1.44 w=0.65 l=0.15 sa=5.08 sb=1.48
X12 VGND.t4 a_1325_21# Y.t1 VNB.t0 sky130_fd_pr__nfet_01v8 ad=0.169 pd=1.82 as=0.11375 ps=1 w=0.65 l=0.15 sa=6.3 sb=0.26
X13 a_435_47.t1 B.t0 VGND.t6 VNB.t7 sky130_fd_pr__nfet_01v8 ad=0.11375 pd=1 as=0.25675 ps=1.44 w=0.65 l=0.15 sa=1.7 sb=4.86
X14 a_923_297# a_535_47.t6 a_823_297.t1 VPB.t9 sky130_fd_pr__pfet_01v8_hvt ad=0.26 pd=2.52 as=0.175 ps=1.35 w=1 l=0.15 sa=0.76 sb=0.26
X15 a_1029_297.t2 a_535_47.t5 VPWR.t3 VPB.t8 sky130_fd_pr__pfet_01v8_hvt ad=0.175 pd=1.35 as=0.285 ps=1.57 w=1 l=0.15 sa=0.98 sb=0.76
X16 Y.t2 a_535_47.t3 a_1111_47.t1 VNB.t8 sky130_fd_pr__nfet_01v8 ad=0.11375 pd=1 as=0.18525 ps=1.22 w=0.65 l=0.15 sa=5.8 sb=0.76
X17 a_535_47.t0 a_581_199# a_353_297.t0 VPB.t1 sky130_fd_pr__pfet_01v8_hvt ad=0.26 pd=2.52 as=0.175 ps=1.35 w=1 l=0.15 sa=1.26 sb=0.26
X18 a_823_297.t0 C.t3 VPWR.t4 VPB.t2 sky130_fd_pr__pfet_01v8_hvt ad=0.175 pd=1.35 as=0.26 ps=2.52 w=1 l=0.15 sa=0.26 sb=0.76
X19 VPWR.t5 C.t2 a_1029_297.t1 VPB.t3 sky130_fd_pr__pfet_01v8_hvt ad=0.285 pd=1.57 as=0.26 ps=2.52 w=1 l=0.15 sa=0.26 sb=1.48
R0 VGND.n1 VGND.n0 9.3005
R1 VGND.n3 VGND.n2 9.3005
R2 VGND.n5 VGND.n4 9.3005
R3 VGND.n7 VGND.n6 9.3005
R4 VGND.n9 VGND.n8 9.3005
R5 VGND.n11 VGND.n10 9.3005
R6 VGND.n13 VGND.n12 9.3005
R7 VGND.n15 VGND.n14 9.3005
R8 VGND.n17 VGND.n16 9.3005
R9 VGND.n19 VGND.n18 9.3005
R10 VGND VGND.n28 0.0226354
R11 VGND.n28 VGND.n1 0.120292
R12 VGND.n1 VGND.n3 0.120292
R13 VGND.n3 VGND.n5 0.120292
R14 VGND.n5 VGND.n7 0.120292
R15 VGND.n7 VGND.n9 0.120292
R16 VGND.n9 VGND.n11 0.120292
R17 VGND.n11 VGND.n13 0.120292
R18 VGND.n13 VGND.n15 0.120292
R19 VGND.n15 VGND.n17 0.120292
R20 VGND.n17 VGND.n19 0.120292
R21 VGND.n19 VGND.n20 0.173395
R22 VGND.n20 VGND.t4 303.493
R23 VGND.n28 VGND.n27 25.8652
R24 VGND.n27 VGND.n0 18.0711
R25 VGND.n0 VGND.n2 34.6358
R26 VGND.n2 VGND.n4 34.6358
R27 VGND.n4 VGND.n26 1.50638
R28 VGND.n26 VGND.n6 33.1299
R29 VGND.n6 VGND.n8 34.6358
R30 VGND.n8 VGND.n10 34.6358
R31 VGND.n10 VGND.n12 34.6358
R32 VGND.n12 VGND.n24 9.03579
R33 VGND.n24 VGND.n14 25.6005
R34 VGND.n14 VGND.n16 34.6358
R35 VGND.n16 VGND.n18 34.6358
R36 VGND.n18 VGND.n22 13.5534
R37 VGND.n22 VGND.n20 28.6573
R38 VGND.n27 VGND.t0 160.222
R39 VGND.n26 VGND.n25 207.213
R40 VGND.n25 VGND.t3 72.9236
R41 VGND.n25 VGND.t6 72.9236
R42 VGND.n24 VGND.n23 207.213
R43 VGND.n23 VGND.t5 72.9236
R44 VGND.n23 VGND.t1 72.9236
R45 VGND.n22 VGND.n21 207.213
R46 VGND.n21 VGND.t7 72.9236
R47 VGND.n21 VGND.t2 72.9236
R48 Y Y.n6 20.4005
R49 Y.n0 Y.n1 185
R50 Y.n1 Y.n2 185
R51 Y Y.n0 6.4005
R52 Y.n0 Y.n6 12.8005
R53 Y.n6 Y.n2 12.8005
R54 Y.n4 Y.n3 585
R55 Y.n5 Y.n4 585
R56 Y.n2 Y.n5 121.882
R57 Y.n5 Y 7.41868
R58 Y Y.n3 2.47323
R59 Y Y.n3 6.92243
R60 Y.n4 Y.t0 26.5955
R61 Y.n1 Y.t2 32.3082
R62 Y.n1 Y.t1 32.3082
R63 VPWR.n2 VPWR.n1 9.3005
R64 VPWR.n4 VPWR.n3 9.3005
R65 VPWR.n6 VPWR.n5 9.3005
R66 VPWR.n8 VPWR.n7 9.3005
R67 VPWR.n10 VPWR.n9 9.3005
R68 VPWR.n12 VPWR.n11 9.3005
R69 VPWR.n14 VPWR.n13 9.3005
R70 VPWR VPWR.n0 0.0226354
R71 VPWR.n0 VPWR.n2 0.120292
R72 VPWR.n2 VPWR.n4 0.120292
R73 VPWR.n4 VPWR.n6 0.120292
R74 VPWR.n6 VPWR.n8 0.120292
R75 VPWR.n8 VPWR.n10 0.120292
R76 VPWR.n10 VPWR.n12 0.120292
R77 VPWR.n12 VPWR.n14 0.120292
R78 VPWR.n14 VPWR.n15 0.153877
R79 VPWR.n15 VPWR.n20 617.879
R80 VPWR.n0 VPWR.n16 25.8652
R81 VPWR.n16 VPWR.n1 18.0711
R82 VPWR.n1 VPWR.n3 34.6358
R83 VPWR.n3 VPWR.n5 34.6358
R84 VPWR.n5 VPWR.n7 34.6358
R85 VPWR.n7 VPWR.n18 21.0829
R86 VPWR.n9 VPWR.n18 13.5534
R87 VPWR.n9 VPWR.n11 34.6358
R88 VPWR.n11 VPWR.n13 34.6358
R89 VPWR.n13 VPWR.n19 28.6123
R90 VPWR.n15 VPWR.n19 13.618
R91 VPWR.n20 VPWR.t5 56.1455
R92 VPWR.n20 VPWR.t3 56.1455
R93 VPWR.n19 VPWR.t4 876.193
R94 VPWR.n18 VPWR.n17 607.212
R95 VPWR.n17 VPWR.t1 34.4755
R96 VPWR.n17 VPWR.t0 34.4755
R97 VPWR.n16 VPWR.t2 347.57
R98 C.n1 C.n0 152
R99 C C.n1 6.4005
R100 C.n3 C.n1 128
R101 C C.n3 0.376971
R102 C.n3 C.n2 158.024
R103 C.n2 C.t0 169.237
R104 C.n2 C.t2 241.536
R105 C.n0 C.t1 169.237
R106 C.n0 C.t3 241.536
R107 A.n1 A.n0 152
R108 A A.n1 6.4005
R109 A.n3 A.n1 128
R110 A A.n3 0.376971
R111 A.n3 A.n2 158.024
R112 A.n2 A.t0 169.237
R113 A.n2 A.t2 241.536
R114 A.n0 A.t1 169.237
R115 A.n0 A.t3 241.536
R116 B.n1 B.n0 152
R117 B B.n1 3.29747
R118 B.n3 B.n2 152
R119 B B.n3 3.29747
R120 B.n3 B.n1 128.571
R121 B.n2 B.t0 169.237
R122 B.n2 B.t2 241.536
R123 B.n0 B.t1 169.237
R124 B.n0 B.t3 241.536
R125 VPB VPB.t6 304.829
R126 VPB.t6 VPB.t4 295.95
R127 VPB.t4 VPB.t7 556.386
R128 VPB.t7 VPB.t5 295.95
R129 VPB.t5 VPB.t1 295.95
R130 VPB.t1 VPB.t2 556.386
R131 VPB.t2 VPB.t9 295.95
R132 VPB.t9 VPB.t3 556.386
R133 VPB.t3 VPB.t8 426.168
R134 VPB.t8 VPB.t0 295.95
R135 VNB VNB.t6 1466.67
R136 VNB.t6 VNB.t4 1423.95
R137 VNB.t4 VNB.t7 2677.02
R138 VNB.t7 VNB.t5 1423.95
R139 VNB.t5 VNB.t1 1423.95
R140 VNB.t1 VNB.t2 2677.02
R141 VNB.t2 VNB.t9 1423.95
R142 VNB.t9 VNB.t3 2677.02
R143 VNB.t3 VNB.t8 2050.49
R144 VNB.t8 VNB.t0 1423.95
R145 a_1111_47.t0 a_1111_47.t1 105.231
R146 a_823_47.t0 a_823_47.t1 64.6159
R147 a_435_47.t0 a_435_47.t1 64.6159
R148 a_147_47.t0 a_147_47.t1 64.6159
R149 a_1029_297.n0 a_1029_297.t2 34.4755
R150 a_1029_297.t0 a_1029_297.n0 34.4755
R151 a_1029_297.n0 a_1029_297.t1 700.169
R152 a_823_297.t0 a_823_297.t1 68.9505
R153 a_353_297.n0 a_353_297.t2 577.768
R154 a_353_297.n0 a_353_297.t1 34.4755
R155 a_353_297.t0 a_353_297.n0 34.4755
R156 a_147_297.t0 a_147_297.t1 68.9505
R157 a_535_47.t0 a_535_47.n4 333.688
R158 a_535_47.n4 a_535_47.n3 315.545
R159 a_535_47.n3 a_535_47.t2 32.3082
R160 a_535_47.n3 a_535_47.t1 32.3082
R161 a_535_47.n4 a_535_47.n1 88.3815
R162 a_535_47.n1 a_535_47.n2 302.122
R163 a_535_47.n2 a_535_47.t3 169.237
R164 a_535_47.n2 a_535_47.t5 241.536
R165 a_535_47.n1 a_535_47.n0 168.097
R166 a_535_47.n0 a_535_47.t4 169.237
R167 a_535_47.n0 a_535_47.t6 241.536
C0 a_581_199# C 0.00943f
C1 C Y 0.00549f
C2 VPB VPWR 0.21934f
C3 a_1325_21# Y 0.05181f
C4 a_247_297# VPB 0.00501f
C5 a_581_199# VGND 0.01598f
C6 VPWR A 0.03552f
C7 VGND Y 0.07152f
C8 a_247_297# A 0.00607f
C9 a_1325_21# C 0
C10 B VGND 0.04884f
C11 C VGND 0.09118f
C12 a_923_297# Y 0
C13 a_1325_21# VGND 0.01749f
C14 VPB A 0.06305f
C15 a_923_297# C 0
C16 a_581_199# VPWR 0.01741f
C17 VPWR Y 0.03907f
C18 a_923_297# VGND 0.00171f
C19 VPWR B 0.05626f
C20 a_247_297# B 0.01528f
C21 VPWR C 0.0342f
C22 a_581_199# VPB 0.03447f
C23 a_1325_21# VPWR 0.01663f
C24 VPB Y 0.02318f
C25 VPWR VGND 0.08727f
C26 VPB B 0.08551f
C27 a_581_199# A 0.03207f
C28 a_247_297# VGND 0.00159f
C29 VPB C 0.07019f
C30 A B 0.14401f
C31 a_1325_21# VPB 0.03501f
C32 a_923_297# VPWR 0.026f
C33 VPB VGND 0.02109f
C34 A VGND 0.09328f
C35 a_923_297# VPB 0.00448f
C36 a_581_199# Y 0
C37 a_247_297# VPWR 0.03567f
C38 a_581_199# B 0
C39 VGND VNB 0.0815f
C40 Y VNB 0f
C41 VPWR VNB 0f
C42 C VNB 0f
C43 A VNB 0f
C44 B VNB 0f
C45 VPB VNB 0.90559f
C46 a_923_297# VNB 0.02383f
C47 a_247_297# VNB 0.02638f
C48 a_535_47.t0 VNB 0.07785f
C49 a_535_47.n0 VNB 0.04965f
C50 a_535_47.n1 VNB 0.15352f
C51 a_535_47.n2 VNB 0.08351f
C52 a_535_47.t2 VNB 0.03682f
C53 a_535_47.t1 VNB 0.05094f
C54 a_535_47.n3 VNB 0.0633f
C55 a_535_47.n4 VNB 0.16543f
C56 a_147_297.t0 VNB 0.04456f
C57 a_147_297.t1 VNB 0.04294f
C58 a_353_297.t0 VNB 0.01911f
C59 a_353_297.n0 VNB 0.1171f
C60 a_353_297.t2 VNB 0.1271f
C61 a_353_297.t1 VNB 0.0455f
C62 a_823_297.t0 VNB 0.04302f
C63 a_823_297.t1 VNB 0.04151f
C64 a_1029_297.t0 VNB 0.06212f
C65 a_1029_297.n0 VNB 0.10379f
C66 a_1029_297.t1 VNB 0.14101f
C67 a_1029_297.t2 VNB 0.04419f
C68 a_147_47.t0 VNB 0.04653f
C69 a_147_47.t1 VNB 0.04535f
C70 a_435_47.t0 VNB 0.03084f
C71 a_435_47.t1 VNB 0.02966f
C72 a_823_47.t0 VNB 0.04604f
C73 a_823_47.t1 VNB 0.04496f
C74 a_1111_47.t0 VNB 0.03786f
C75 a_1111_47.t1 VNB 0.03678f
C76 VPB.t0 VNB 0.0982f
C77 VPB.t1 VNB 0.06427f
C78 VPB.t2 VNB 0.06427f
C79 VPB.t3 VNB 0.07409f
C80 VPB.t4 VNB 0.06427f
C81 VPB.t5 VNB 0.04463f
C82 VPB.t6 VNB 0.0453f
C83 VPB.t7 VNB 0.06427f
C84 VPB.t8 VNB 0.05445f
C85 VPB.t9 VNB 0.06427f
C86 B.n0 VNB 0.04956f
C87 B.n1 VNB 0.06295f
C88 B.n2 VNB 0.04956f
C89 B.n3 VNB 0.06295f
C90 A.n0 VNB 0.05282f
C91 A.n1 VNB 0.06192f
C92 A.n2 VNB 0.05328f
C93 A.n3 VNB 0.06945f
C94 C.n0 VNB 0.05073f
C95 C.n1 VNB 0.05947f
C96 C.n2 VNB 0.05117f
C97 C.n3 VNB 0.0667f
C98 VPWR.n0 VNB 0.02438f
C99 VPWR.n1 VNB 0.00864f
C100 VPWR.n2 VNB 0.03207f
C101 VPWR.n3 VNB 0.01136f
C102 VPWR.n4 VNB 0.03207f
C103 VPWR.n5 VNB 0.01136f
C104 VPWR.n6 VNB 0.03207f
C105 VPWR.n7 VNB 0.00914f
C106 VPWR.n8 VNB 0.03207f
C107 VPWR.n9 VNB 0.0079f
C108 VPWR.n10 VNB 0.03207f
C109 VPWR.n11 VNB 0.01136f
C110 VPWR.n12 VNB 0.03207f
C111 VPWR.n13 VNB 0.01037f
C112 VPWR.n14 VNB 0.05173f
C113 VPWR.n15 VNB 0.32851f
C114 VPWR.t2 VNB 0.06171f
C115 VPWR.n16 VNB 0.02926f
C116 VPWR.t1 VNB 0.03746f
C117 VPWR.t0 VNB 0.03909f
C118 VPWR.n17 VNB 0.0257f
C119 VPWR.n18 VNB 0.01676f
C120 VPWR.t4 VNB 0.05956f
C121 VPWR.n19 VNB 0.02567f
C122 VPWR.t5 VNB 0.04604f
C123 VPWR.t3 VNB 0.04453f
C124 VPWR.n20 VNB 0.04227f
C125 Y.n0 VNB 0.00456f
C126 Y.n1 VNB 0.02391f
C127 Y.t2 VNB 0.02919f
C128 Y.t1 VNB 0.01196f
C129 Y.n2 VNB 0.03686f
C130 Y.n3 VNB 0.01156f
C131 Y.n4 VNB 0.04047f
C132 Y.t0 VNB 0.05595f
C133 Y.n5 VNB 0.05488f
C134 Y.n6 VNB 0.01894f
C135 VGND.n0 VNB 0.00574f
C136 VGND.n1 VNB 0.02128f
C137 VGND.n2 VNB 0.00754f
C138 VGND.n3 VNB 0.02128f
C139 VGND.n4 VNB 0.00393f
C140 VGND.n5 VNB 0.02128f
C141 VGND.n6 VNB 0.00737f
C142 VGND.n7 VNB 0.02128f
C143 VGND.n8 VNB 0.00754f
C144 VGND.n9 VNB 0.02128f
C145 VGND.n10 VNB 0.00754f
C146 VGND.n11 VNB 0.02128f
C147 VGND.n12 VNB 0.00475f
C148 VGND.n13 VNB 0.02128f
C149 VGND.n14 VNB 0.00655f
C150 VGND.n15 VNB 0.02128f
C151 VGND.n16 VNB 0.00754f
C152 VGND.n17 VNB 0.02128f
C153 VGND.n18 VNB 0.00524f
C154 VGND.n19 VNB 0.04216f
C155 VGND.n20 VNB 0.12775f
C156 VGND.t4 VNB 0.01581f
C157 VGND.t7 VNB 0.0296f
C158 VGND.t2 VNB 0.03069f
C159 VGND.n21 VNB 0.0253f
C160 VGND.n22 VNB 0.01277f
C161 VGND.t5 VNB 0.04557f
C162 VGND.t1 VNB 0.03069f
C163 VGND.n23 VNB 0.0253f
C164 VGND.n24 VNB 0.01076f
C165 VGND.t3 VNB 0.03145f
C166 VGND.t6 VNB 0.03027f
C167 VGND.n25 VNB 0.0253f
C168 VGND.n26 VNB 0.01076f
C169 VGND.t0 VNB 0.03315f
C170 VGND.n27 VNB 0.01992f
C171 VGND.n28 VNB 0.01618f
.ends
