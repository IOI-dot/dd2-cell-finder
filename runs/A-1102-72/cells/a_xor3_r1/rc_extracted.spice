* NGSPICE file created from a_xor3_r1.ext - technology: sky130A

.subckt a_xor3_r1 A B C VGND VNB VPB VPWR Y
X0 a_804_297# A VPWR VPB.t6 sky130_fd_pr__pfet_01v8_hvt ad=0.4 pd=1.8 as=0.135 ps=1.27 w=1 l=0.15 sa=0.68 sb=1.21
X1 VGND a_666_21# a_392_21# VNB sky130_fd_pr__nfet_01v8 ad=0.26 pd=1.45 as=0.08775 ps=0.92 w=0.65 l=0.15 sa=3 sb=4.47
X2 a_1348_297# B VPWR VPB.t3 sky130_fd_pr__pfet_01v8_hvt ad=0.4 pd=1.8 as=0.26 ps=2.52 w=1 l=0.15 sa=0.26 sb=1.21
X3 VPWR B a_804_297# VPB.t2 sky130_fd_pr__pfet_01v8_hvt ad=0.135 pd=1.27 as=0.26 ps=2.52 w=1 l=0.15 sa=0.26 sb=1.63
X4 a_970_47# A a_886_47# VNB sky130_fd_pr__nfet_01v8 ad=0.26 pd=1.45 as=0.08775 ps=0.92 w=0.65 l=0.15 sa=4.37 sb=3.1
X5 a_1073_199# B VGND VNB sky130_fd_pr__nfet_01v8 ad=0.26 pd=1.45 as=0.25675 ps=1.44 w=0.65 l=0.15 sa=6.26 sb=1.21
X6 a_66_297# a_251_199# VPWR VPB.t0 sky130_fd_pr__pfet_01v8_hvt ad=0.135 pd=1.27 as=0.4 ps=1.8 w=1 l=0.15 sa=1.21 sb=0.68
X7 a_148_47# C VGND VNB sky130_fd_pr__nfet_01v8 ad=0.26 pd=1.45 as=0.169 ps=1.82 w=0.65 l=0.15 sa=0.26 sb=7.21
X8 a_886_47# B VGND VNB sky130_fd_pr__nfet_01v8 ad=0.08775 pd=0.92 as=0.26 ps=1.45 w=0.65 l=0.15 sa=3.95 sb=3.52
X9 VGND a_1073_199# a_970_47# VNB sky130_fd_pr__nfet_01v8 ad=0.25675 pd=1.44 as=0.26 ps=1.45 w=0.65 l=0.15 sa=5.32 sb=2.15
X10 a_392_21# a_666_21# a_612_297# VPB.t5 sky130_fd_pr__pfet_01v8_hvt ad=0.26 pd=2.52 as=0.135 ps=1.27 w=1 l=0.15 sa=0.68 sb=0.26
X11 VGND a_392_21# Y.t2 VNB sky130_fd_pr__nfet_01v8 ad=0.26 pd=1.45 as=0.08775 ps=0.92 w=0.65 l=0.15 sa=1.63 sb=5.84
X12 VGND A a_1073_199# VNB sky130_fd_pr__nfet_01v8 ad=0.169 pd=1.82 as=0.26 ps=1.45 w=0.65 l=0.15 sa=7.21 sb=0.26
X13 a_612_297# C VPWR VPB.t9 sky130_fd_pr__pfet_01v8_hvt ad=0.135 pd=1.27 as=0.26 ps=2.52 w=1 l=0.15 sa=0.26 sb=0.68
X14 VPWR C a_66_297# VPB.t8 sky130_fd_pr__pfet_01v8_hvt ad=0.4 pd=1.8 as=0.26 ps=2.52 w=1 l=0.15 sa=0.26 sb=1.63
X15 Y.t0 a_251_199# a_148_47# VNB sky130_fd_pr__nfet_01v8 ad=0.08775 pd=0.92 as=0.26 ps=1.45 w=0.65 l=0.15 sa=1.21 sb=6.26
X16 a_1160_297# a_1073_199# a_804_297# VPB.t4 sky130_fd_pr__pfet_01v8_hvt ad=0.26 pd=2.52 as=0.4 ps=1.8 w=1 l=0.15 sa=1.63 sb=0.26
X17 a_1073_199# A a_1348_297# VPB.t7 sky130_fd_pr__pfet_01v8_hvt ad=0.26 pd=2.52 as=0.4 ps=1.8 w=1 l=0.15 sa=1.21 sb=0.26
X18 a_392_21# C VGND VNB sky130_fd_pr__nfet_01v8 ad=0.08775 pd=0.92 as=0.26 ps=1.45 w=0.65 l=0.15 sa=2.58 sb=4.89
X19 Y.t1 a_392_21# a_66_297# VPB.t1 sky130_fd_pr__pfet_01v8_hvt ad=0.26 pd=2.52 as=0.135 ps=1.27 w=1 l=0.15 sa=1.63 sb=0.26
R0 Y Y.t1 331.384
R1 Y.n0 Y 194.892
R2 Y.n1 Y.n0 185
R3 Y.n0 Y.t2 24.9236
R4 Y.n0 Y.t0 24.9236
R5 Y Y.n1 20.0244
R6 Y.n1 Y 3.29747
R7 VPB.t8 VPB.t0 562.306
R8 VPB.t1 VPB.t9 562.306
R9 VPB.t5 VPB.t2 562.306
R10 VPB.t6 VPB.t4 562.306
R11 VPB.t3 VPB.t7 562.306
R12 VPB.t4 VPB.t3 556.386
R13 VPB VPB.t8 307.788
R14 VPB.t0 VPB.t1 248.599
R15 VPB.t9 VPB.t5 248.599
R16 VPB.t2 VPB.t6 248.599
C0 Y VPB 0.02553f
C1 a_1073_199# VPB 0.08544f
C2 VPWR VPB 0.25938f
C3 a_66_297# Y 0.03934f
C4 a_970_47# B 0.04921f
C5 a_804_297# a_886_47# 0
C6 a_66_297# VPWR 0.13611f
C7 a_804_297# a_392_21# 0.03267f
C8 a_148_47# VGND 0.03374f
C9 a_666_21# VGND 0.02899f
C10 A a_1348_297# 0.00931f
C11 a_804_297# B 0.0428f
C12 a_392_21# VPB 0.06052f
C13 a_148_47# Y 0.01256f
C14 a_66_297# a_392_21# 0.00996f
C15 Y a_666_21# 0.00735f
C16 B VPB 0.08566f
C17 a_1073_199# a_666_21# 0
C18 a_148_47# VPWR 0
C19 a_666_21# VPWR 0.01665f
C20 a_1160_297# A 0.00885f
C21 C VPB 0.08917f
C22 a_970_47# A 0.01628f
C23 a_66_297# C 0.05069f
C24 a_148_47# a_392_21# 0
C25 a_666_21# a_392_21# 0.05755f
C26 Y VGND 0.10789f
C27 a_1073_199# VGND 0.09207f
C28 VPWR VGND 0.04195f
C29 a_612_297# VGND 0
C30 a_804_297# A 0.04817f
C31 a_666_21# B 0.02476f
C32 Y a_1073_199# 0.00139f
C33 A VPB 0.09158f
C34 a_148_47# C 0.01243f
C35 C a_666_21# 0.02548f
C36 Y VPWR 0.07891f
C37 a_612_297# Y 0.00225f
C38 a_886_47# VGND 0.00434f
C39 a_1073_199# VPWR 0.08619f
C40 a_612_297# a_1073_199# 0
C41 a_612_297# VPWR 0.01453f
C42 a_392_21# VGND 0.10781f
C43 B VGND 0.20713f
C44 Y a_886_47# 0
C45 a_886_47# VPWR 0
C46 Y a_392_21# 0.10525f
C47 a_1073_199# a_392_21# 0.00163f
C48 a_251_199# VPB 0.03925f
C49 a_392_21# VPWR 0.07486f
C50 C VGND 0.0596f
C51 a_612_297# a_392_21# 0.01366f
C52 Y B 0.00489f
C53 a_66_297# a_251_199# 0.03098f
C54 a_666_21# A 0
C55 a_1073_199# B 0.12491f
C56 B VPWR 0.03578f
C57 a_1160_297# a_1348_297# 0.00478f
C58 Y C 0.12983f
C59 C VPWR 0.07909f
C60 a_886_47# B 0.00929f
C61 a_392_21# B 0.0036f
C62 a_148_47# a_251_199# 0.00481f
C63 A VGND 0.08727f
C64 C a_392_21# 0.10744f
C65 Y A 0.00431f
C66 a_1073_199# A 0.17435f
C67 A VPWR 0.07195f
C68 a_804_297# a_1160_297# 0.0277f
C69 a_251_199# VGND 0.01794f
C70 a_804_297# a_970_47# 0.00293f
C71 a_1160_297# VPB 0.00734f
C72 Y a_251_199# 0.00885f
C73 a_392_21# A 0
C74 a_970_47# VPB 0
C75 a_251_199# VPWR 0.01459f
C76 A B 0.13359f
C77 a_804_297# VPB 0.01184f
C78 a_392_21# a_251_199# 0.032f
C79 VGND a_1348_297# 0
C80 a_66_297# VPB 0.01855f
C81 C a_251_199# 0.04526f
C82 Y a_1348_297# 0
C83 a_1073_199# a_1348_297# 0.04127f
C84 VPWR a_1348_297# 0.03037f
C85 a_666_21# VPB 0.03956f
C86 a_970_47# VGND 0.0115f
C87 a_148_47# a_66_297# 0.00156f
C88 a_1160_297# Y 0
C89 a_1160_297# a_1073_199# 0.02946f
C90 a_1160_297# VPWR 0.03951f
C91 Y a_970_47# 0.00119f
C92 a_1073_199# a_970_47# 0.00661f
C93 a_804_297# VGND 0.00315f
C94 a_970_47# VPWR 0
C95 B a_1348_297# 0
C96 VPB VGND 0.02113f
C97 a_804_297# Y 0.00235f
C98 a_1160_297# a_392_21# 0
C99 a_804_297# a_1073_199# 0.01357f
C100 a_66_297# VGND 0.0105f
C101 a_970_47# a_886_47# 0
C102 a_804_297# VPWR 0.12086f
C103 a_1160_297# B 0.00189f
C104 VGND VNB 1.24017f
C105 Y VNB 0.25752f
C106 VPWR VNB 0.94396f
C107 VPB VNB 1.72534f
C108 a_970_47# VNB 0.0873f
C109 a_148_47# VNB 0.09883f
C110 a_1348_297# VNB 0.09301f
C111 a_1160_297# VNB 0
C112 a_804_297# VNB 0.09813f
C113 a_66_297# VNB 0.07176f
C114 VPB.t7 VNB 0.12834f
C115 VPB.t3 VNB 0.09119f
C116 VPB.t4 VNB 0.09119f
C117 VPB.t6 VNB 0.0661f
C118 VPB.t2 VNB 0.0661f
C119 VPB.t5 VNB 0.0661f
C120 VPB.t9 VNB 0.0661f
C121 VPB.t1 VNB 0.0661f
C122 VPB.t0 VNB 0.0661f
C123 VPB.t8 VNB 0.07093f
C124 Y.t1 VNB 0.09186f
C125 Y.t2 VNB 0.0852f
C126 Y.t0 VNB 0.01623f
C127 Y.n0 VNB 0.03377f
C128 Y.n1 VNB 0.14901f
.ends
