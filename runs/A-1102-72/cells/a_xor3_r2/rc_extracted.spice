* NGSPICE file created from a_xor3_r2.ext - technology: sky130A

.subckt a_xor3_r2 A B C VGND VNB VPB VPWR Y
X0 a_341_297# A VPWR VPB.t3 sky130_fd_pr__pfet_01v8_hvt ad=0.4 pd=1.8 as=0.135 ps=1.27 w=1 l=0.15 sa=0.68 sb=1.21
X1 a_1263_297# a_885_47# Y.t1 VPB.t4 sky130_fd_pr__pfet_01v8_hvt ad=0.4 pd=1.8 as=0.26 ps=2.52 w=1 l=0.15 sa=0.26 sb=1.63
X2 Y.t2 a_885_47# VGND VNB sky130_fd_pr__nfet_01v8 ad=0.26 pd=1.45 as=0.25675 ps=1.44 w=0.65 l=0.15 sa=5.83 sb=1.63
X3 VGND a_149_47# a_507_47# VNB sky130_fd_pr__nfet_01v8 ad=0.25675 pd=1.44 as=0.26 ps=1.45 w=0.65 l=0.15 sa=3 sb=4.46
X4 VPWR B a_341_297# VPB.t9 sky130_fd_pr__pfet_01v8_hvt ad=0.135 pd=1.27 as=0.26 ps=2.52 w=1 l=0.15 sa=0.26 sb=1.63
X5 VGND A a_149_47# VNB sky130_fd_pr__nfet_01v8 ad=0.26 pd=1.45 as=0.08775 ps=0.92 w=0.65 l=0.15 sa=0.68 sb=6.78
X6 a_1453_47# a_507_47# Y.t0 VNB sky130_fd_pr__nfet_01v8 ad=0.08775 pd=0.92 as=0.26 ps=1.45 w=0.65 l=0.15 sa=6.78 sb=0.68
X7 a_149_47# B VGND VNB sky130_fd_pr__nfet_01v8 ad=0.08775 pd=0.92 as=0.169 ps=1.82 w=0.65 l=0.15 sa=0.26 sb=7.2
X8 a_885_47# C VGND VNB sky130_fd_pr__nfet_01v8 ad=0.26 pd=1.45 as=0.25675 ps=1.44 w=0.65 l=0.15 sa=3.94 sb=3.52
X9 a_423_47# B VGND VNB sky130_fd_pr__nfet_01v8 ad=0.08775 pd=0.92 as=0.26 ps=1.45 w=0.65 l=0.15 sa=1.63 sb=5.83
X10 VGND C a_1453_47# VNB sky130_fd_pr__nfet_01v8 ad=0.169 pd=1.82 as=0.08775 ps=0.92 w=0.65 l=0.15 sa=7.2 sb=0.26
X11 a_1263_297# C VPWR VPB.t7 sky130_fd_pr__pfet_01v8_hvt ad=0.26 pd=2.52 as=0.135 ps=1.27 w=1 l=0.15 sa=1.63 sb=0.26
X12 VGND a_507_47# a_885_47# VNB sky130_fd_pr__nfet_01v8 ad=0.25675 pd=1.44 as=0.26 ps=1.45 w=0.65 l=0.15 sa=4.89 sb=2.57
X13 a_507_47# a_149_47# a_341_297# VPB.t5 sky130_fd_pr__pfet_01v8_hvt ad=0.26 pd=2.52 as=0.4 ps=1.8 w=1 l=0.15 sa=1.63 sb=0.26
X14 VPWR a_507_47# a_1263_297# VPB.t1 sky130_fd_pr__pfet_01v8_hvt ad=0.135 pd=1.27 as=0.4 ps=1.8 w=1 l=0.15 sa=1.21 sb=0.68
X15 a_149_47# A a_149_297# VPB.t2 sky130_fd_pr__pfet_01v8_hvt ad=0.26 pd=2.52 as=0.135 ps=1.27 w=1 l=0.15 sa=0.68 sb=0.26
X16 a_885_47# a_507_47# a_885_297# VPB.t0 sky130_fd_pr__pfet_01v8_hvt ad=0.26 pd=2.52 as=0.4 ps=1.8 w=1 l=0.15 sa=1.21 sb=0.26
X17 a_507_47# A a_423_47# VNB sky130_fd_pr__nfet_01v8 ad=0.26 pd=1.45 as=0.08775 ps=0.92 w=0.65 l=0.15 sa=2.05 sb=5.41
X18 a_149_297# B VPWR VPB.t8 sky130_fd_pr__pfet_01v8_hvt ad=0.135 pd=1.27 as=0.26 ps=2.52 w=1 l=0.15 sa=0.26 sb=0.68
X19 a_885_297# C VPWR VPB.t6 sky130_fd_pr__pfet_01v8_hvt ad=0.4 pd=1.8 as=0.26 ps=2.52 w=1 l=0.15 sa=0.26 sb=1.21
R0 Y Y.t1 837.274
R1 Y.n0 Y 194.892
R2 Y.n1 Y.n0 185
R3 Y.n0 Y.t0 73.8467
R4 Y.n0 Y.t2 73.8467
R5 Y Y.n1 21.1902
R6 Y.n1 Y 3.29747
R7 VPB.t2 VPB.t9 562.306
R8 VPB.t3 VPB.t5 562.306
R9 VPB.t6 VPB.t0 562.306
R10 VPB.t4 VPB.t1 562.306
R11 VPB.t5 VPB.t6 556.386
R12 VPB.t0 VPB.t4 556.386
R13 VPB VPB.t8 310.748
R14 VPB.t8 VPB.t2 248.599
R15 VPB.t9 VPB.t3 248.599
R16 VPB.t1 VPB.t7 248.599
C0 VPWR A 0.03216f
C1 VPWR a_341_297# 0.119f
C2 VPWR a_149_297# 0.01472f
C3 a_507_47# a_423_47# 0.00266f
C4 Y a_885_297# 0.01182f
C5 A VPB 0.07947f
C6 VPB a_341_297# 0.00715f
C7 VPWR VPB 0.25112f
C8 VGND a_149_47# 0.08195f
C9 C a_885_297# 0.00139f
C10 VPWR a_885_47# 0.0179f
C11 A a_507_47# 0.01992f
C12 a_507_47# a_341_297# 0.02334f
C13 VPWR a_507_47# 0.15186f
C14 a_1263_297# VPWR 0.12068f
C15 Y a_149_47# 0.00739f
C16 VPB a_885_47# 0.05532f
C17 VPB a_507_47# 0.13171f
C18 a_1263_297# VPB 0.01686f
C19 C a_149_47# 0.00871f
C20 a_507_47# a_885_47# 0.16919f
C21 Y VGND 0.17535f
C22 a_1263_297# a_885_47# 0.00391f
C23 a_1263_297# a_507_47# 0.07201f
C24 a_1453_47# a_885_47# 0
C25 C VGND 0.08213f
C26 B a_149_47# 0.09815f
C27 VPWR a_885_297# 0.02593f
C28 a_1263_297# a_1453_47# 0.00187f
C29 a_149_47# a_423_47# 0
C30 Y C 0.2271f
C31 VGND B 0.09153f
C32 a_885_47# a_885_297# 0.00139f
C33 VGND a_423_47# 0.0079f
C34 A a_149_47# 0.13173f
C35 a_149_47# a_341_297# 0.10323f
C36 a_507_47# a_885_297# 0.04182f
C37 VPWR a_149_47# 0.08759f
C38 Y B 0.00333f
C39 a_1263_297# a_885_297# 0.00176f
C40 a_149_297# a_149_47# 0.01368f
C41 VGND A 0.08651f
C42 VGND a_341_297# 0.00556f
C43 VPB a_149_47# 0.07436f
C44 Y a_423_47# 0
C45 VPWR VGND 0.03652f
C46 a_149_47# a_885_47# 0
C47 a_149_47# a_507_47# 0.07538f
C48 VGND VPB 0.01947f
C49 Y A 0.00302f
C50 Y a_341_297# 0.00156f
C51 Y VPWR 0.05567f
C52 VGND a_885_47# 0.10979f
C53 Y a_149_297# 0
C54 VGND a_507_47# 0.12343f
C55 C VPWR 0.06063f
C56 Y VPB 0.01875f
C57 a_1263_297# VGND 0.00437f
C58 Y a_885_47# 0.12134f
C59 VGND a_1453_47# 0.0123f
C60 Y a_507_47# 0.13817f
C61 C VPB 0.08989f
C62 A B 0.14346f
C63 B a_341_297# 0.01676f
C64 VPWR B 0.07994f
C65 Y a_1263_297# 0.00465f
C66 C a_885_47# 0.06382f
C67 B a_149_297# 0.00313f
C68 C a_507_47# 0.15613f
C69 Y a_1453_47# 0.00423f
C70 A a_423_47# 0.00608f
C71 C a_1263_297# 0.05416f
C72 VPWR a_423_47# 0
C73 B VPB 0.08482f
C74 C a_1453_47# 0.00288f
C75 B a_507_47# 0.00176f
C76 A a_341_297# 0.0129f
C77 VGND VNB 1.12291f
C78 Y VNB 0.32227f
C79 VPWR VNB 0.92952f
C80 VPB VNB 1.72511f
C81 a_1453_47# VNB 0.12459f
C82 a_1263_297# VNB 0.08491f
C83 a_341_297# VNB 0.17993f
C84 a_885_47# VNB 0.10535f
C85 VPB.t7 VNB 0.10242f
C86 VPB.t1 VNB 0.06557f
C87 VPB.t4 VNB 0.09045f
C88 VPB.t0 VNB 0.09045f
C89 VPB.t6 VNB 0.09045f
C90 VPB.t5 VNB 0.09045f
C91 VPB.t3 VNB 0.06557f
C92 VPB.t9 VNB 0.06557f
C93 VPB.t2 VNB 0.06557f
C94 VPB.t8 VNB 0.04523f
C95 Y.t1 VNB 0.13747f
C96 Y.t0 VNB 0.16983f
C97 Y.t2 VNB 0.04525f
C98 Y.n0 VNB 0.09173f
C99 Y.n1 VNB 0.22602f
.ends
