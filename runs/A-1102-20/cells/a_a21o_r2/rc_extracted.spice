* NGSPICE file created from a_a21o_r2.ext - technology: sky130A

.subckt a_a21o_r2 A B C VGND VNB VPB VPWR Y
X0 VGND B a_243_47# VNB sky130_fd_pr__nfet_01v8 ad=0.25675 pd=1.44 as=0.11375 ps=1 w=0.65 l=0.15 sa=1.26 sb=1.2
X1 a_143_297# B VPWR VPB sky130_fd_pr__pfet_01v8_hvt ad=0.26 pd=2.52 as=0.175 ps=1.35 w=1 l=0.15 sa=1.26 sb=0.26
X2 a_243_47# A a_61_297# VNB sky130_fd_pr__nfet_01v8 ad=0.11375 pd=1 as=0.11375 ps=1 w=0.65 l=0.15 sa=0.76 sb=1.7
X3 VPWR A a_143_297# VPB sky130_fd_pr__pfet_01v8_hvt ad=0.175 pd=1.35 as=0.175 ps=1.35 w=1 l=0.15 sa=0.76 sb=0.76
X4 Y a_61_297# VPWR VPB sky130_fd_pr__pfet_01v8_hvt ad=0.26 pd=2.52 as=0.26 ps=2.52 w=1 l=0.15 sa=0.26 sb=0.26
X5 Y a_61_297# VGND VNB sky130_fd_pr__nfet_01v8 ad=0.169 pd=1.82 as=0.25675 ps=1.44 w=0.65 l=0.15 sa=2.2 sb=0.26
X6 a_61_297# C VGND VNB sky130_fd_pr__nfet_01v8 ad=0.11375 pd=1 as=0.169 ps=1.82 w=0.65 l=0.15 sa=0.26 sb=2.2
X7 a_143_297# C a_61_297# VPB sky130_fd_pr__pfet_01v8_hvt ad=0.175 pd=1.35 as=0.26 ps=2.52 w=1 l=0.15 sa=0.26 sb=1.26
C0 C VPB 0.03235f
C1 C VPWR 0.01269f
C2 A VPB 0.0282f
C3 A VPWR 0.01567f
C4 A B 0.03085f
C5 a_243_47# a_61_297# 0.01211f
C6 a_143_297# a_61_297# 0.08492f
C7 VPB VPWR 0.10935f
C8 VPWR B 0.01619f
C9 VPB B 0.03257f
C10 C a_143_297# 0.00441f
C11 A a_143_297# 0.01326f
C12 Y VGND 0.04241f
C13 a_243_47# VPWR 0.0011f
C14 VPB a_143_297# 0.00831f
C15 a_143_297# VPWR 0.11983f
C16 a_143_297# B 0.01272f
C17 a_61_297# VGND 0.13852f
C18 Y a_61_297# 0.04749f
C19 C VGND 0.02979f
C20 A VGND 0.01373f
C21 A Y 0
C22 VPWR VGND 0.03727f
C23 VPB VGND 0.01366f
C24 B VGND 0.01551f
C25 Y VPWR 0.07517f
C26 VPB Y 0.01779f
C27 C a_61_297# 0.03652f
C28 Y B 0
C29 A a_61_297# 0.04705f
C30 A C 0.03085f
C31 a_243_47# VGND 0.01002f
C32 VPB a_61_297# 0.06771f
C33 VPWR a_61_297# 0.08611f
C34 a_143_297# VGND 0.00381f
C35 B a_61_297# 0.06519f
C36 a_243_47# Y 0
C37 VGND VNB 0.50225f
C38 Y VNB 0.18148f
C39 VPWR VNB 0.41289f
C40 VPB VNB 0.69336f
C41 a_243_47# VNB 0.06131f
C42 a_143_297# VNB 0
C43 a_61_297# VNB 0.04481f
.ends
