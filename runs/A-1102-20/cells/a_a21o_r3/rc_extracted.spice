* NGSPICE file created from a_a21o_r3.ext - technology: sky130A

.subckt a_a21o_r3 A B C VGND VNB VPB VPWR Y
X0 VPWR a_97_199# Y VPB sky130_fd_pr__pfet_01v8_hvt ad=0.26 pd=2.52 as=0.26 ps=2.52 w=1 l=0.15 sa=0.26 sb=0.26
X1 VPWR A a_339_297# VPB sky130_fd_pr__pfet_01v8_hvt ad=0.135 pd=1.27 as=0.175 ps=1.35 w=1 l=0.15 sa=0.76 sb=0.68
X2 VGND B a_439_47# VNB sky130_fd_pr__nfet_01v8 ad=0.169 pd=1.82 as=0.08775 ps=0.92 w=0.65 l=0.15 sa=2.12 sb=0.26
X3 a_439_47# A a_97_199# VNB sky130_fd_pr__nfet_01v8 ad=0.08775 pd=0.92 as=0.11375 ps=1 w=0.65 l=0.15 sa=1.7 sb=0.68
X4 a_339_297# C a_97_199# VPB sky130_fd_pr__pfet_01v8_hvt ad=0.175 pd=1.35 as=0.26 ps=2.52 w=1 l=0.15 sa=0.26 sb=1.18
X5 a_97_199# C VGND VNB sky130_fd_pr__nfet_01v8 ad=0.11375 pd=1 as=0.25675 ps=1.44 w=0.65 l=0.15 sa=1.2 sb=1.18
X6 a_339_297# B VPWR VPB sky130_fd_pr__pfet_01v8_hvt ad=0.26 pd=2.52 as=0.135 ps=1.27 w=1 l=0.15 sa=1.18 sb=0.26
X7 VGND a_97_199# Y VNB sky130_fd_pr__nfet_01v8 ad=0.25675 pd=1.44 as=0.169 ps=1.82 w=0.65 l=0.15 sa=0.26 sb=2.12
C0 VPB VPWR 0.09994f
C1 VPWR Y 0.05119f
C2 C a_97_199# 0.05682f
C3 VPWR B 0.01524f
C4 A a_97_199# 0.01224f
C5 A C 0.03085f
C6 a_439_47# VGND 0.01234f
C7 VPB a_97_199# 0.0624f
C8 Y a_97_199# 0.07019f
C9 a_339_297# VGND 0.0085f
C10 B a_97_199# 0.0032f
C11 a_439_47# VPWR 0.00122f
C12 a_339_297# VPWR 0.10565f
C13 C VPB 0.03389f
C14 C Y 0
C15 A VPB 0.02801f
C16 A B 0.03192f
C17 a_439_47# a_97_199# 0.0044f
C18 a_339_297# a_97_199# 0.0384f
C19 VPB Y 0.02338f
C20 VPB B 0.032f
C21 a_439_47# A 0
C22 C a_339_297# 0.00792f
C23 A a_339_297# 0.029f
C24 VPWR VGND 0.03753f
C25 a_439_47# B 0
C26 VPB a_339_297# 0.02205f
C27 a_339_297# B 0.02856f
C28 a_97_199# VGND 0.11333f
C29 VPWR a_97_199# 0.08848f
C30 C VGND 0.01592f
C31 A VGND 0.02012f
C32 a_439_47# a_339_297# 0.00146f
C33 C VPWR 0.0157f
C34 A VPWR 0.01659f
C35 VPB VGND 0.01373f
C36 Y VGND 0.04991f
C37 B VGND 0.0301f
C38 VGND VNB 0.48779f
C39 VPWR VNB 0.41171f
C40 Y VNB 0.16972f
C41 VPB VNB 0.69336f
C42 a_439_47# VNB 0.04462f
C43 a_339_297# VNB 0.09513f
.ends
