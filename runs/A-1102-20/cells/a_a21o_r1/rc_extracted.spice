* NGSPICE file created from a_a21o_r1.ext - technology: sky130A

.subckt a_a21o_r1 A B C VGND VNB VPB VPWR Y
X0 VPWR a_97_199# Y VPB sky130_fd_pr__pfet_01v8_hvt ad=0.26 pd=2.52 as=0.26 ps=2.52 w=1 l=0.15 sa=0.26 sb=0.26
X1 a_257_297# A VPWR VPB sky130_fd_pr__pfet_01v8_hvt ad=0.135 pd=1.27 as=0.175 ps=1.35 w=1 l=0.15 sa=0.76 sb=0.68
X2 VGND C a_97_199# VNB sky130_fd_pr__nfet_01v8 ad=0.169 pd=1.82 as=0.08775 ps=0.92 w=0.65 l=0.15 sa=2.12 sb=0.26
X3 a_97_199# A a_339_47# VNB sky130_fd_pr__nfet_01v8 ad=0.08775 pd=0.92 as=0.11375 ps=1 w=0.65 l=0.15 sa=1.7 sb=0.68
X4 VPWR B a_257_297# VPB sky130_fd_pr__pfet_01v8_hvt ad=0.175 pd=1.35 as=0.26 ps=2.52 w=1 l=0.15 sa=0.26 sb=1.18
X5 a_339_47# B VGND VNB sky130_fd_pr__nfet_01v8 ad=0.11375 pd=1 as=0.25675 ps=1.44 w=0.65 l=0.15 sa=1.2 sb=1.18
X6 a_97_199# C a_257_297# VPB sky130_fd_pr__pfet_01v8_hvt ad=0.26 pd=2.52 as=0.135 ps=1.27 w=1 l=0.15 sa=1.18 sb=0.26
X7 VGND a_97_199# Y VNB sky130_fd_pr__nfet_01v8 ad=0.25675 pd=1.44 as=0.169 ps=1.82 w=0.65 l=0.15 sa=0.26 sb=2.12
C0 C VGND 0.01599f
C1 VPB VPWR 0.10265f
C2 VPWR Y 0.08504f
C3 B a_97_199# 0.03802f
C4 VPWR C 0.01504f
C5 A a_97_199# 0.02819f
C6 A B 0.03085f
C7 a_339_47# VGND 0.01005f
C8 VPB a_97_199# 0.06852f
C9 Y a_97_199# 0.05219f
C10 a_257_297# VGND 0.0042f
C11 C a_97_199# 0.04958f
C12 a_339_47# VPWR 0.0011f
C13 a_257_297# VPWR 0.14204f
C14 B VPB 0.03314f
C15 B Y 0
C16 A Y 0
C17 A VPB 0.02804f
C18 A C 0.03192f
C19 a_339_47# a_97_199# 0.01222f
C20 a_257_297# a_97_199# 0.04248f
C21 VPB Y 0.02334f
C22 VPB C 0.03395f
C23 Y C 0
C24 B a_257_297# 0.02817f
C25 A a_257_297# 0.0255f
C26 VPWR VGND 0.03647f
C27 a_339_47# Y 0
C28 VPB a_257_297# 0.01143f
C29 a_257_297# Y 0
C30 a_257_297# C 0.01123f
C31 a_97_199# VGND 0.1471f
C32 VPWR a_97_199# 0.07067f
C33 B VGND 0.01575f
C34 A VGND 0.01296f
C35 B VPWR 0.01628f
C36 A VPWR 0.01582f
C37 VPB VGND 0.00999f
C38 Y VGND 0.04982f
C39 VGND VNB 0.47014f
C40 VPWR VNB 0.47995f
C41 Y VNB 0.21303f
C42 VPB VNB 0.69336f
C43 a_257_297# VNB 0.06567f
.ends
