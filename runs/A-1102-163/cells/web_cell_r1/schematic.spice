.subckt web_cell_r1 A B S VGND VNB VPB VPWR Y
X0 _s1 S VGND VNB sky130_fd_pr__nfet_01v8 w=650000u l=150000u
X1 _s2 _s1 n1 VNB sky130_fd_pr__nfet_01v8 w=650000u l=150000u
X2 n1 A VGND VNB sky130_fd_pr__nfet_01v8 w=650000u l=150000u
X3 _s2 B n2 VNB sky130_fd_pr__nfet_01v8 w=650000u l=150000u
X4 n2 S VGND VNB sky130_fd_pr__nfet_01v8 w=650000u l=150000u
X5 Y _s2 VGND VNB sky130_fd_pr__nfet_01v8 w=650000u l=150000u
X6 _s1 S VPWR VPB sky130_fd_pr__pfet_01v8_hvt w=1000000u l=150000u
X7 _s2 _s1 p1 VPB sky130_fd_pr__pfet_01v8_hvt w=1000000u l=150000u
X8 _s2 A p1 VPB sky130_fd_pr__pfet_01v8_hvt w=1000000u l=150000u
X9 p1 B VPWR VPB sky130_fd_pr__pfet_01v8_hvt w=1000000u l=150000u
X10 p1 S VPWR VPB sky130_fd_pr__pfet_01v8_hvt w=1000000u l=150000u
X11 Y _s2 VPWR VPB sky130_fd_pr__pfet_01v8_hvt w=1000000u l=150000u
.ends
