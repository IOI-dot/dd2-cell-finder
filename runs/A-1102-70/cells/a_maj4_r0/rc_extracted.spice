* NGSPICE file created from a_maj4_r0.ext - technology: sky130A

.subckt a_maj4_r0 A B C D VGND VNB VPB VPWR Y
X0 a_133_297# B a_51_297# VPB sky130_fd_pr__pfet_01v8_hvt ad=0.165 pd=1.33 as=0.26 ps=2.52 w=1 l=0.15 sa=0.26 sb=3.22
X1 a_51_297# C a_229_47# VNB sky130_fd_pr__nfet_01v8 ad=0.10725 pd=0.98 as=0.13325 ps=1.06 w=0.65 l=0.15 sa=1.3 sb=2.18
X2 a_133_47# B VGND VNB sky130_fd_pr__nfet_01v8 ad=0.10725 pd=0.98 as=0.169 ps=1.82 w=0.65 l=0.15 sa=0.26 sb=3.22
X3 a_533_47# C a_229_47# VNB sky130_fd_pr__nfet_01v8 ad=0.10725 pd=0.98 as=0.10725 ps=0.98 w=0.65 l=0.15 sa=2.26 sb=1.22
X4 a_229_47# D a_51_297# VNB sky130_fd_pr__nfet_01v8 ad=0.10725 pd=0.98 as=0.10725 ps=0.98 w=0.65 l=0.15 sa=1.78 sb=1.7
X5 Y a_51_297# VPWR VPB sky130_fd_pr__pfet_01v8_hvt ad=0.26 pd=2.52 as=0.165 ps=1.33 w=1 l=0.15 sa=3.22 sb=0.26
X6 VPWR D a_133_297# VPB sky130_fd_pr__pfet_01v8_hvt ad=0.165 pd=1.33 as=0.165 ps=1.33 w=1 l=0.15 sa=2.74 sb=0.74
X7 Y a_51_297# VGND VNB sky130_fd_pr__nfet_01v8 ad=0.169 pd=1.82 as=0.10725 ps=0.98 w=0.65 l=0.15 sa=3.22 sb=0.26
X8 a_51_297# A a_133_297# VPB sky130_fd_pr__pfet_01v8_hvt ad=0.205 pd=1.41 as=0.165 ps=1.33 w=1 l=0.15 sa=0.74 sb=2.74
X9 VGND D a_533_47# VNB sky130_fd_pr__nfet_01v8 ad=0.10725 pd=0.98 as=0.10725 ps=0.98 w=0.65 l=0.15 sa=2.74 sb=0.74
X10 a_341_297# C a_51_297# VPB sky130_fd_pr__pfet_01v8_hvt ad=0.165 pd=1.33 as=0.205 ps=1.41 w=1 l=0.15 sa=1.3 sb=2.18
X11 a_133_297# C VPWR VPB sky130_fd_pr__pfet_01v8_hvt ad=0.165 pd=1.33 as=0.165 ps=1.33 w=1 l=0.15 sa=2.26 sb=1.22
X12 a_229_47# A a_133_47# VNB sky130_fd_pr__nfet_01v8 ad=0.13325 pd=1.06 as=0.10725 ps=0.98 w=0.65 l=0.15 sa=0.74 sb=2.74
X13 VPWR D a_341_297# VPB sky130_fd_pr__pfet_01v8_hvt ad=0.165 pd=1.33 as=0.165 ps=1.33 w=1 l=0.15 sa=1.78 sb=1.7
C0 C A 0.01678f
C1 a_229_47# Y 0.00161f
C2 VPWR VPB 0.11606f
C3 a_229_47# VPB 0
C4 a_133_297# VGND 0.00527f
C5 VGND D 0.02539f
C6 a_341_297# VGND 0
C7 Y VPB 0.01786f
C8 VPWR B 0.01186f
C9 B a_229_47# 0
C10 a_133_47# A 0.00114f
C11 B Y 0
C12 VGND C 0.02488f
C13 a_51_297# A 0.04026f
C14 B VPB 0.03123f
C15 a_133_297# a_533_47# 0.00172f
C16 D a_533_47# 0
C17 a_133_297# VPWR 0.16929f
C18 VPWR D 0.06478f
C19 a_341_297# VPWR 0.00697f
C20 a_133_297# a_229_47# 0
C21 a_229_47# D 0.01723f
C22 a_133_297# Y 0
C23 Y D 0.00269f
C24 a_133_47# VGND 0.01172f
C25 a_133_297# VPB 0.00865f
C26 D VPB 0.05573f
C27 C a_533_47# 0.00114f
C28 a_51_297# VGND 0.11654f
C29 C VPWR 0.03902f
C30 C a_229_47# 0.01403f
C31 C Y 0.00268f
C32 a_133_297# B 0.00267f
C33 B D 0
C34 C VPB 0.06303f
C35 VGND A 0.01799f
C36 a_51_297# a_533_47# 0.00635f
C37 a_133_47# VPWR 0.00149f
C38 a_51_297# VPWR 0.07814f
C39 a_133_47# a_229_47# 0.00198f
C40 a_133_297# D 0.0261f
C41 a_51_297# a_229_47# 0.06448f
C42 a_341_297# a_133_297# 0.01327f
C43 a_341_297# D 0
C44 a_133_47# Y 0
C45 a_51_297# Y 0.07717f
C46 a_51_297# VPB 0.05074f
C47 a_133_297# C 0.06843f
C48 C D 0.16342f
C49 a_341_297# C 0.00678f
C50 VPWR A 0.01024f
C51 a_51_297# B 0.02747f
C52 a_229_47# A 0.00175f
C53 Y A 0
C54 A VPB 0.02823f
C55 VGND a_533_47# 0.01025f
C56 a_133_297# a_51_297# 0.06339f
C57 a_51_297# D 0.13345f
C58 VGND VPWR 0.02726f
C59 a_341_297# a_51_297# 0.00322f
C60 B A 0.03636f
C61 VGND a_229_47# 0.09004f
C62 VGND Y 0.0425f
C63 VGND VPB 0.01277f
C64 a_51_297# C 0.0661f
C65 a_133_297# A 0.01069f
C66 A D 0
C67 VGND B 0.02229f
C68 a_229_47# a_533_47# 0.00284f
C69 VPWR a_229_47# 0.0014f
C70 Y a_533_47# 0.00195f
C71 VPWR Y 0.06848f
C72 a_133_47# a_51_297# 0.00532f
C73 VGND VNB 0.50165f
C74 Y VNB 0.26042f
C75 VPWR VNB 0.56148f
C76 VPB VNB 0.87055f
C77 a_229_47# VNB 0.12585f
C78 a_133_297# VNB 0.08044f
C79 a_51_297# VNB 0.03002f
.ends
