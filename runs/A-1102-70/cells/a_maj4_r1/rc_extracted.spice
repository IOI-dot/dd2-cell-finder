* NGSPICE file created from a_maj4_r1.ext - technology: sky130A

.subckt a_maj4_r1 A B C D VGND VNB VPB VPWR Y
X0 a_680_47# A a_355_47# VNB sky130_fd_pr__nfet_01v8 ad=0.20638 pd=1.285 as=0.08775 ps=0.92 w=0.65 l=0.15 sa=3.09 sb=1.045
X1 a_439_297# D VPWR VPB sky130_fd_pr__pfet_01v8_hvt ad=0.3175 pd=1.635 as=0.135 ps=1.27 w=1 l=0.15 sa=1.885 sb=2.25
X2 a_355_47# C a_198_47# VNB sky130_fd_pr__nfet_01v8 ad=0.08775 pd=0.92 as=0.20638 ps=1.285 w=0.65 l=0.15 sa=1.465 sb=2.67
X3 VPWR C a_198_297# VPB sky130_fd_pr__pfet_01v8_hvt ad=0.135 pd=1.27 as=0.3175 ps=1.635 w=1 l=0.15 sa=1.465 sb=2.67
X4 a_198_47# D VGND VNB sky130_fd_pr__nfet_01v8 ad=0.20638 pd=1.285 as=0.08775 ps=0.92 w=0.65 l=0.15 sa=0.68 sb=3.455
X5 VGND a_60_199# Y VNB sky130_fd_pr__nfet_01v8 ad=0.08775 pd=0.92 as=0.169 ps=1.82 w=0.65 l=0.15 sa=0.26 sb=3.875
X6 a_355_47# C a_60_199# VNB sky130_fd_pr__nfet_01v8 ad=0.08775 pd=0.92 as=0.20638 ps=1.285 w=0.65 l=0.15 sa=2.67 sb=1.465
X7 a_198_297# D VPWR VPB sky130_fd_pr__pfet_01v8_hvt ad=0.3175 pd=1.635 as=0.135 ps=1.27 w=1 l=0.15 sa=0.68 sb=3.455
X8 a_60_199# D a_355_47# VNB sky130_fd_pr__nfet_01v8 ad=0.20638 pd=1.285 as=0.08775 ps=0.92 w=0.65 l=0.15 sa=1.885 sb=2.25
X9 VGND B a_680_47# VNB sky130_fd_pr__nfet_01v8 ad=0.169 pd=1.82 as=0.20638 ps=1.285 w=0.65 l=0.15 sa=3.875 sb=0.26
X10 a_60_199# B a_198_297# VPB sky130_fd_pr__pfet_01v8_hvt ad=0.26 pd=2.52 as=0.3175 ps=1.635 w=1 l=0.15 sa=3.875 sb=0.26
X11 a_198_297# A a_60_199# VPB sky130_fd_pr__pfet_01v8_hvt ad=0.3175 pd=1.635 as=0.135 ps=1.27 w=1 l=0.15 sa=3.09 sb=1.045
X12 VPWR a_60_199# Y VPB sky130_fd_pr__pfet_01v8_hvt ad=0.135 pd=1.27 as=0.26 ps=2.52 w=1 l=0.15 sa=0.26 sb=3.875
X13 a_60_199# C a_439_297# VPB sky130_fd_pr__pfet_01v8_hvt ad=0.135 pd=1.27 as=0.3175 ps=1.635 w=1 l=0.15 sa=2.67 sb=1.465
C0 a_355_47# VPB 0
C1 a_198_297# VGND 0.00731f
C2 VGND B 0.02604f
C3 VPWR VPB 0.1206f
C4 Y D 0.00973f
C5 D a_355_47# 0.008f
C6 a_198_47# C 0
C7 VGND A 0.02021f
C8 D VPWR 0.05208f
C9 a_60_199# C 0.10419f
C10 D VPB 0.09001f
C11 B a_680_47# 0.00229f
C12 a_198_297# Y 0.00201f
C13 Y B 0
C14 a_439_297# Y 0.00109f
C15 a_355_47# B 0.00139f
C16 a_198_297# VPWR 0.2045f
C17 VPWR B 0.01213f
C18 a_439_297# VPWR 0.01739f
C19 a_198_47# VGND 0.01816f
C20 a_198_297# VPB 0.00837f
C21 B VPB 0.03452f
C22 A a_680_47# 0.00481f
C23 a_60_199# VGND 0.10589f
C24 A Y 0
C25 A a_355_47# 0.00648f
C26 A VPWR 0.00957f
C27 a_198_297# D 0.06977f
C28 D B 0
C29 a_439_297# D 0.00485f
C30 A VPB 0.03817f
C31 VGND C 0.03491f
C32 a_60_199# a_680_47# 0.00495f
C33 a_198_47# Y 0.00278f
C34 a_60_199# Y 0.06641f
C35 a_198_47# a_355_47# 0.00359f
C36 A D 0
C37 a_198_297# B 0.00365f
C38 a_60_199# a_355_47# 0.09545f
C39 a_439_297# a_198_297# 0.02967f
C40 a_198_47# VPWR 0.00183f
C41 a_60_199# VPWR 0.0838f
C42 a_60_199# VPB 0.0538f
C43 a_198_297# A 0.01223f
C44 A B 0.02541f
C45 Y C 0.00551f
C46 a_60_199# D 0.11064f
C47 a_355_47# C 0.02588f
C48 VPWR C 0.04715f
C49 C VPB 0.06371f
C50 VGND a_680_47# 0.02703f
C51 a_198_297# a_60_199# 0.10126f
C52 a_60_199# B 0.03062f
C53 VGND Y 0.04445f
C54 a_439_297# a_60_199# 0.00856f
C55 D C 0.14826f
C56 VGND a_355_47# 0.10314f
C57 VGND VPWR 0.02819f
C58 VGND VPB 0.00793f
C59 a_60_199# A 0.03826f
C60 a_198_297# C 0.03805f
C61 a_439_297# C 0.00827f
C62 Y a_680_47# 0
C63 VGND D 0.02671f
C64 a_355_47# a_680_47# 0.0081f
C65 Y a_355_47# 0.00124f
C66 VPWR a_680_47# 0.00286f
C67 Y VPWR 0.07421f
C68 a_198_47# a_60_199# 0.01589f
C69 A C 0.03088f
C70 a_355_47# VPWR 0
C71 Y VPB 0.01512f
C72 VGND VNB 0.69521f
C73 VPWR VNB 0.51183f
C74 Y VNB 0.19596f
C75 VPB VNB 0.95915f
C76 a_680_47# VNB 0.08478f
C77 a_355_47# VNB 0.10391f
C78 a_198_47# VNB 0.06009f
C79 a_439_297# VNB 0.08276f
C80 a_198_297# VNB 0.00111f
.ends
