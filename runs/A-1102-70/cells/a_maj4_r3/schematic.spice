.subckt a_maj4_r3 A B C D VGND VNB VPB VPWR Y
X0 _s1 C n1 VNB sky130_fd_pr__nfet_01v8 w=650000u l=150000u
X1 _s1 D n1 VNB sky130_fd_pr__nfet_01v8 w=650000u l=150000u
X2 n1 A n2 VNB sky130_fd_pr__nfet_01v8 w=650000u l=150000u
X3 n2 B VGND VNB sky130_fd_pr__nfet_01v8 w=650000u l=150000u
X4 n1 C n3 VNB sky130_fd_pr__nfet_01v8 w=650000u l=150000u
X5 n3 D VGND VNB sky130_fd_pr__nfet_01v8 w=650000u l=150000u
X6 Y _s1 VGND VNB sky130_fd_pr__nfet_01v8 w=650000u l=150000u
X7 _s1 C p1 VPB sky130_fd_pr__pfet_01v8_hvt w=1000000u l=150000u
X8 p1 D VPWR VPB sky130_fd_pr__pfet_01v8_hvt w=1000000u l=150000u
X9 _s1 A p2 VPB sky130_fd_pr__pfet_01v8_hvt w=1000000u l=150000u
X10 _s1 B p2 VPB sky130_fd_pr__pfet_01v8_hvt w=1000000u l=150000u
X11 p2 C VPWR VPB sky130_fd_pr__pfet_01v8_hvt w=1000000u l=150000u
X12 p2 D VPWR VPB sky130_fd_pr__pfet_01v8_hvt w=1000000u l=150000u
X13 Y _s1 VPWR VPB sky130_fd_pr__pfet_01v8_hvt w=1000000u l=150000u
.ends
