* NGSPICE file created from a_maj4_r3.ext - technology: sky130A

.subckt a_maj4_r3 A B C D VGND VNB VPB VPWR Y
X0 a_573_47# A a_416_47# VNB sky130_fd_pr__nfet_01v8 ad=0.08775 pd=0.92 as=0.20638 ps=1.285 w=0.65 l=0.15 sa=1.465 sb=1.885
X1 a_416_47# B VGND VNB sky130_fd_pr__nfet_01v8 ad=0.20638 pd=1.285 as=0.08775 ps=0.92 w=0.65 l=0.15 sa=0.68 sb=2.67
X2 a_332_297# D VPWR VPB sky130_fd_pr__pfet_01v8_hvt ad=0.135 pd=1.27 as=0.395 ps=1.79 w=1 l=0.15 sa=1.2 sb=3.09
X3 a_114_21# C a_814_297# VPB sky130_fd_pr__pfet_01v8_hvt ad=0.26 pd=2.52 as=0.135 ps=1.27 w=1 l=0.15 sa=4.03 sb=0.26
X4 a_573_47# D a_114_21# VNB sky130_fd_pr__nfet_01v8 ad=0.08775 pd=0.92 as=0.20638 ps=1.285 w=0.65 l=0.15 sa=2.67 sb=0.68
X5 a_814_297# D VPWR VPB sky130_fd_pr__pfet_01v8_hvt ad=0.135 pd=1.27 as=0.3175 ps=1.635 w=1 l=0.15 sa=3.61 sb=0.68
X6 a_114_21# C a_573_47# VNB sky130_fd_pr__nfet_01v8 ad=0.20638 pd=1.285 as=0.08775 ps=0.92 w=0.65 l=0.15 sa=1.885 sb=1.465
X7 a_898_47# C a_573_47# VNB sky130_fd_pr__nfet_01v8 ad=0.169 pd=1.82 as=0.08775 ps=0.92 w=0.65 l=0.15 sa=3.09 sb=0.26
X8 VGND a_114_21# Y VNB sky130_fd_pr__nfet_01v8 ad=0.169 pd=1.82 as=0.169 ps=1.82 w=0.65 l=0.15 sa=0.26 sb=0.26
X9 VPWR C a_332_297# VPB sky130_fd_pr__pfet_01v8_hvt ad=0.3175 pd=1.635 as=0.135 ps=1.27 w=1 l=0.15 sa=2.825 sb=1.465
X10 a_332_297# A a_114_21# VPB sky130_fd_pr__pfet_01v8_hvt ad=0.135 pd=1.27 as=0.3175 ps=1.635 w=1 l=0.15 sa=2.405 sb=1.885
X11 a_114_21# B a_332_297# VPB sky130_fd_pr__pfet_01v8_hvt ad=0.3175 pd=1.635 as=0.135 ps=1.27 w=1 l=0.15 sa=1.62 sb=2.67
X12 VPWR a_114_21# Y VPB sky130_fd_pr__pfet_01v8_hvt ad=0.395 pd=1.79 as=0.26 ps=2.52 w=1 l=0.15 sa=0.26 sb=4.03
X13 VGND D a_250_47# VNB sky130_fd_pr__nfet_01v8 ad=0.08775 pd=0.92 as=0.169 ps=1.82 w=0.65 l=0.15 sa=0.26 sb=3.09
C0 Y a_416_47# 0
C1 D a_573_47# 0.02229f
C2 VPWR C 0.03619f
C3 a_573_47# B 0
C4 a_114_21# a_898_47# 0.00229f
C5 VPWR A 0.00885f
C6 C VGND 0.02351f
C7 a_573_47# a_416_47# 0.00359f
C8 Y a_573_47# 0
C9 D VPB 0.08074f
C10 VGND A 0.01069f
C11 a_332_297# VPB 0.00547f
C12 C a_114_21# 0.11332f
C13 B VPB 0.03028f
C14 D a_250_47# 0.0053f
C15 Y VPB 0.01704f
C16 a_114_21# A 0.05196f
C17 VPWR a_814_297# 0.00918f
C18 VPWR D 0.07691f
C19 VPWR a_332_297# 0.11862f
C20 Y a_250_47# 0
C21 VGND a_814_297# 0.00151f
C22 a_573_47# VPB 0
C23 VPWR B 0.00802f
C24 VGND D 0.08071f
C25 C a_898_47# 0.0066f
C26 VPWR Y 0.04838f
C27 a_573_47# a_250_47# 0
C28 VGND B 0.01402f
C29 A a_898_47# 0
C30 a_114_21# a_814_297# 0.01418f
C31 VGND a_416_47# 0.01805f
C32 Y VGND 0.04308f
C33 a_114_21# D 0.17534f
C34 VPWR a_573_47# 0.00112f
C35 a_114_21# a_332_297# 0.08987f
C36 a_114_21# B 0.04476f
C37 C A 0.03318f
C38 a_114_21# a_416_47# 0.01523f
C39 VGND a_573_47# 0.09907f
C40 Y a_114_21# 0.05718f
C41 VPWR VPB 0.13753f
C42 D a_898_47# 0
C43 a_114_21# a_573_47# 0.05831f
C44 B a_898_47# 0
C45 VGND VPB 0.01091f
C46 VPWR a_250_47# 0
C47 C a_814_297# 0.00288f
C48 a_898_47# a_416_47# 0
C49 C D 0.12568f
C50 VGND a_250_47# 0.0353f
C51 C a_332_297# 0.00409f
C52 a_114_21# VPB 0.06806f
C53 C B 0
C54 A D 0.02017f
C55 a_573_47# a_898_47# 0.0144f
C56 VPWR VGND 0.02957f
C57 A a_332_297# 0.00763f
C58 Y C 0
C59 A B 0.02541f
C60 a_114_21# a_250_47# 0.01529f
C61 Y A 0
C62 VPWR a_114_21# 0.16871f
C63 C a_573_47# 0.02402f
C64 a_898_47# VPB 0
C65 A a_573_47# 0.00277f
C66 a_114_21# VGND 0.09677f
C67 a_332_297# a_814_297# 0
C68 D a_332_297# 0.01546f
C69 D B 0.04899f
C70 C VPB 0.07416f
C71 a_332_297# B 0.0111f
C72 D a_416_47# 0.00484f
C73 VPWR a_898_47# 0.00103f
C74 Y D 0.00172f
C75 Y a_332_297# 0.00336f
C76 A VPB 0.03845f
C77 Y B 0
C78 VGND a_898_47# 0.01601f
C79 VGND VNB 0.72892f
C80 VPWR VNB 0.55232f
C81 Y VNB 0.2047f
C82 VPB VNB 1.04774f
C83 a_898_47# VNB 0.01439f
C84 a_573_47# VNB 0.0502f
C85 a_416_47# VNB 0.06743f
C86 a_250_47# VNB 0.00209f
C87 a_814_297# VNB 0.08112f
C88 a_332_297# VNB 0.08735f
.ends
