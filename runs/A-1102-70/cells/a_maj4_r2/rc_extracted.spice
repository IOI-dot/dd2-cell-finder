* NGSPICE file created from a_maj4_r2.ext - technology: sky130A

.subckt a_maj4_r2 A B C D VGND VNB VPB VPWR Y
X0 a_385_297# B a_62_297# VPB sky130_fd_pr__pfet_01v8_hvt ad=0.135 pd=1.27 as=0.3175 ps=1.635 w=1 l=0.15 sa=2.67 sb=1.62
X1 Y a_62_297# VPWR VPB sky130_fd_pr__pfet_01v8_hvt ad=0.26 pd=2.52 as=0.395 ps=1.79 w=1 l=0.15 sa=4.03 sb=0.26
X2 a_62_297# A a_385_297# VPB sky130_fd_pr__pfet_01v8_hvt ad=0.3175 pd=1.635 as=0.135 ps=1.27 w=1 l=0.15 sa=1.885 sb=2.405
X3 a_385_297# C VPWR VPB sky130_fd_pr__pfet_01v8_hvt ad=0.135 pd=1.27 as=0.3175 ps=1.635 w=1 l=0.15 sa=1.465 sb=2.825
X4 Y a_62_297# VGND VNB sky130_fd_pr__nfet_01v8 ad=0.169 pd=1.82 as=0.169 ps=1.82 w=0.65 l=0.15 sa=0.26 sb=0.26
X5 a_144_47# C a_62_47# VNB sky130_fd_pr__nfet_01v8 ad=0.08775 pd=0.92 as=0.169 ps=1.82 w=0.65 l=0.15 sa=0.26 sb=3.09
X6 VPWR D a_144_297# VPB sky130_fd_pr__pfet_01v8_hvt ad=0.3175 pd=1.635 as=0.135 ps=1.27 w=1 l=0.15 sa=0.68 sb=3.61
X7 a_710_47# D VGND VNB sky130_fd_pr__nfet_01v8 ad=0.169 pd=1.82 as=0.08775 ps=0.92 w=0.65 l=0.15 sa=3.09 sb=0.26
X8 a_144_47# C a_62_297# VNB sky130_fd_pr__nfet_01v8 ad=0.08775 pd=0.92 as=0.20638 ps=1.285 w=0.65 l=0.15 sa=1.465 sb=1.885
X9 a_62_297# D a_144_47# VNB sky130_fd_pr__nfet_01v8 ad=0.20638 pd=1.285 as=0.08775 ps=0.92 w=0.65 l=0.15 sa=0.68 sb=2.67
X10 VGND B a_469_47# VNB sky130_fd_pr__nfet_01v8 ad=0.08775 pd=0.92 as=0.20638 ps=1.285 w=0.65 l=0.15 sa=2.67 sb=0.68
X11 a_144_297# C a_62_297# VPB sky130_fd_pr__pfet_01v8_hvt ad=0.135 pd=1.27 as=0.26 ps=2.52 w=1 l=0.15 sa=0.26 sb=4.03
X12 VPWR D a_385_297# VPB sky130_fd_pr__pfet_01v8_hvt ad=0.395 pd=1.79 as=0.135 ps=1.27 w=1 l=0.15 sa=3.09 sb=1.2
X13 a_469_47# A a_144_47# VNB sky130_fd_pr__nfet_01v8 ad=0.20638 pd=1.285 as=0.08775 ps=0.92 w=0.65 l=0.15 sa=1.885 sb=1.465
C0 a_62_297# VGND 0.09607f
C1 a_144_297# a_385_297# 0
C2 C a_144_297# 0.00288f
C3 D a_385_297# 0.01546f
C4 a_710_47# a_62_47# 0
C5 C D 0.1265f
C6 B VPB 0.03028f
C7 VPWR a_385_297# 0.1186f
C8 C a_144_47# 0.01762f
C9 Y a_710_47# 0
C10 VPWR C 0.03616f
C11 A VPB 0.03845f
C12 VPWR a_144_297# 0.00921f
C13 B a_62_47# 0
C14 D a_144_47# 0.02032f
C15 VPWR D 0.07702f
C16 VGND a_710_47# 0.0353f
C17 VPWR a_144_47# 0.0012f
C18 A a_62_47# 0
C19 Y B 0
C20 a_469_47# D 0.00484f
C21 a_62_297# a_710_47# 0.01529f
C22 Y A 0
C23 B VGND 0.01402f
C24 a_469_47# a_144_47# 0.0034f
C25 VPB a_385_297# 0.00547f
C26 C VPB 0.07412f
C27 VGND A 0.01069f
C28 B a_62_297# 0.04476f
C29 D VPB 0.08074f
C30 C a_62_47# 0.01365f
C31 VPB a_144_47# 0
C32 VPWR VPB 0.1376f
C33 a_62_297# A 0.05195f
C34 Y a_385_297# 0.00336f
C35 D a_62_47# 0.00119f
C36 Y C 0
C37 a_144_47# a_62_47# 0.01452f
C38 VPWR a_62_47# 0
C39 Y D 0.00173f
C40 VGND C 0.02345f
C41 Y a_144_47# 0
C42 VGND a_144_297# 0.00152f
C43 Y VPWR 0.04838f
C44 VGND D 0.08096f
C45 a_469_47# a_62_47# 0
C46 a_62_297# a_385_297# 0.08987f
C47 VGND a_144_47# 0.09354f
C48 VPWR VGND 0.02957f
C49 a_62_297# C 0.11343f
C50 Y a_469_47# 0
C51 a_62_297# a_144_297# 0.01423f
C52 a_62_297# D 0.1758f
C53 B A 0.02541f
C54 a_62_297# a_144_47# 0.05353f
C55 VGND a_469_47# 0.01805f
C56 VPB a_62_47# 0
C57 VPWR a_62_297# 0.1687f
C58 Y VPB 0.01704f
C59 a_62_297# a_469_47# 0.01522f
C60 D a_710_47# 0.0053f
C61 VGND VPB 0.01074f
C62 Y a_62_47# 0
C63 B a_385_297# 0.0111f
C64 a_710_47# a_144_47# 0
C65 VPWR a_710_47# 0
C66 B C 0
C67 VGND a_62_47# 0.02542f
C68 A a_385_297# 0.00763f
C69 a_62_297# VPB 0.06811f
C70 B D 0.04899f
C71 A C 0.03318f
C72 B a_144_47# 0
C73 Y VGND 0.04308f
C74 VPWR B 0.00802f
C75 A D 0.02017f
C76 a_62_297# a_62_47# 0.0063f
C77 A a_144_47# 0.00271f
C78 VPWR A 0.00885f
C79 Y a_62_297# 0.05718f
C80 C a_385_297# 0.00409f
C81 VGND VNB 0.60016f
C82 Y VNB 0.19768f
C83 VPWR VNB 0.72414f
C84 VPB VNB 1.04774f
C85 a_710_47# VNB 0.00209f
C86 a_144_47# VNB 0.00578f
C87 a_62_47# VNB 0.02404f
C88 a_385_297# VNB 0.14851f
C89 a_144_297# VNB 0.08731f
.ends
