* NGSPICE file created from web_cell_r0.ext - technology: sky130A

.subckt web_cell_r0 A B S VGND VNB VPB VPWR Y
X0 a_145_297.t1 A.t1 a_63_47.t1 VPB.t3 sky130_fd_pr__pfet_01v8_hvt ad=0.175 pd=1.35 as=0.26 ps=2.52 w=1 l=0.15 sa=0.26 sb=1.26
X1 a_63_47.t0 B.t1 VGND.t4 VNB.t1 sky130_fd_pr__nfet_01v8 ad=0.11375 pd=1 as=0.11375 ps=1 w=0.65 l=0.15 sa=0.76 sb=2.6
X2 a_533_47.t1 S.t0 VGND.t0 VNB.t5 sky130_fd_pr__nfet_01v8 ad=0.10725 pd=0.98 as=0.25675 ps=1.44 w=0.65 l=0.15 sa=2.2 sb=1.16
X3 Y.t0 a_63_47.t5 a_451_297.t0 VPB.t0 sky130_fd_pr__pfet_01v8_hvt ad=0.26 pd=2.52 as=0.135 ps=1.27 w=1 l=0.15 sa=1.16 sb=0.26
X4 VPWR.t1 S.t3 a_245_297.t1 VPB.t4 sky130_fd_pr__pfet_01v8_hvt ad=0.26 pd=2.52 as=0.175 ps=1.35 w=1 l=0.15 sa=1.26 sb=0.26
X5 VGND.t2 A.t0 a_63_47.t2 VNB.t3 sky130_fd_pr__nfet_01v8 ad=0.11375 pd=1 as=0.169 ps=1.82 w=0.65 l=0.15 sa=0.26 sb=3.1
X6 VGND.t3 a_63_47.t4 Y.t1 VNB.t0 sky130_fd_pr__nfet_01v8 ad=0.169 pd=1.82 as=0.08775 ps=0.92 w=0.65 l=0.15 sa=3.1 sb=0.26
X7 a_451_297.t1 B.t2 VPWR.t2 VPB.t2 sky130_fd_pr__pfet_01v8_hvt ad=0.135 pd=1.27 as=0.165 ps=1.33 w=1 l=0.15 sa=0.74 sb=0.68
X8 Y.t2 B.t0 a_533_47.t0 VNB.t2 sky130_fd_pr__nfet_01v8 ad=0.08775 pd=0.92 as=0.10725 ps=0.98 w=0.65 l=0.15 sa=2.68 sb=0.68
X9 a_245_297.t0 B.t3 a_145_297.t0 VPB.t1 sky130_fd_pr__pfet_01v8_hvt ad=0.175 pd=1.35 as=0.175 ps=1.35 w=1 l=0.15 sa=0.76 sb=0.76
X10 VPWR.t0 S.t2 a_451_297.t2 VPB.t5 sky130_fd_pr__pfet_01v8_hvt ad=0.165 pd=1.33 as=0.26 ps=2.52 w=1 l=0.15 sa=0.26 sb=1.16
X11 VGND.t1 S.t1 a_63_47.t3 VNB.t4 sky130_fd_pr__nfet_01v8 ad=0.25675 pd=1.44 as=0.11375 ps=1 w=0.65 l=0.15 sa=1.26 sb=2.1
R0 VGND.n1 VGND.n0 9.3005
R1 VGND.n3 VGND.n2 9.3005
R2 VGND.n5 VGND.n4 9.3005
R3 VGND VGND.n7 0.121778
R4 VGND.n7 VGND.n1 0.141672
R5 VGND.n1 VGND.n3 0.120292
R6 VGND.n3 VGND.n5 0.120292
R7 VGND.n5 VGND.n6 0.288585
R8 VGND.n6 VGND.t3 303.252
R9 VGND.n7 VGND.n11 23.4709
R10 VGND.n11 VGND.n0 18.824
R11 VGND.n0 VGND.n2 34.6358
R12 VGND.n2 VGND.n4 34.6358
R13 VGND.n4 VGND.n9 3.76521
R14 VGND.n9 VGND.n6 38.3304
R15 VGND.n11 VGND.n10 207.213
R16 VGND.n10 VGND.t2 32.3082
R17 VGND.n10 VGND.t4 32.3082
R18 VGND.n9 VGND.n8 120.698
R19 VGND.n8 VGND.t1 72.9236
R20 VGND.n8 VGND.t0 72.9236
R21 Y.n3 Y 6.8005
R22 Y.n1 Y.n0 185
R23 Y.n0 Y.n3 197.8
R24 Y Y.n3 6.4005
R25 Y Y.n1 6.4005
R26 Y Y.n2 6.4005
R27 Y.n1 Y.n2 110.306
R28 Y Y.n2 6.77697
R29 Y.n2 Y.t0 325.269
R30 Y.n0 Y.t2 24.9236
R31 Y.n0 Y.t1 24.9236
R32 VPWR VPWR.n0 0.785513
R33 VPWR.n0 VPWR.n1 618.991
R34 VPWR.n1 VPWR.t0 32.5055
R35 VPWR.n1 VPWR.t2 32.5055
R36 VPWR.n0 VPWR.t1 269.509
R37 S S.n1 167.165
R38 S.n1 S.n0 137.298
R39 S.n1 S.t3 212.081
R40 S.n1 S.t1 139.78
R41 S.n0 S.t2 212.081
R42 S.n0 S.t0 139.78
R43 B.n1 B.n0 152
R44 B B.n1 6.4005
R45 B.n3 B.n1 25.5806
R46 B B.n3 0.376971
R47 B.n3 B.n2 158.024
R48 B.n2 B.t0 169.237
R49 B.n2 B.t2 241.536
R50 B.n0 B.t1 169.237
R51 B.n0 B.t3 241.536
R52 A A.n0 158.4
R53 A.n0 A.t0 169.237
R54 A.n0 A.t1 241.536
R55 VPB VPB.t3 298.911
R56 VPB.t3 VPB.t1 295.95
R57 VPB.t1 VPB.t4 295.95
R58 VPB.t4 VPB.t5 556.386
R59 VPB.t5 VPB.t2 284.113
R60 VPB.t2 VPB.t0 248.599
R61 VNB VNB.t3 1438.19
R62 VNB.t3 VNB.t1 1423.95
R63 VNB.t1 VNB.t4 1423.95
R64 VNB.t4 VNB.t5 2677.02
R65 VNB.t5 VNB.t2 1366.99
R66 VNB.t2 VNB.t0 1196.12
R67 a_533_47.t0 a_533_47.t1 60.9236
R68 a_451_297.n0 a_451_297.t1 26.5955
R69 a_451_297.t0 a_451_297.n0 26.5955
R70 a_451_297.n0 a_451_297.t2 473.865
R71 a_245_297.t0 a_245_297.t1 68.9505
R72 a_145_297.t0 a_145_297.t1 68.9505
R73 a_63_47.t1 a_63_47.n0 320.949
R74 a_63_47.n1 a_63_47.n2 92.501
R75 a_63_47.n0 a_63_47.n1 68.6683
R76 a_63_47.n1 a_63_47.n3 197.871
R77 a_63_47.n3 a_63_47.t4 169.237
R78 a_63_47.n3 a_63_47.t5 241.536
R79 a_63_47.n2 a_63_47.t0 32.3082
R80 a_63_47.n2 a_63_47.t3 32.3082
R81 a_63_47.n0 a_63_47.t2 131.8
C0 B VGND 0.04029f
C1 VPWR B 0.07776f
C2 A B 0.03372f
C3 VPB VGND 0.01176f
C4 VPB VPWR 0.13994f
C5 Y VGND 0.06929f
C6 VPWR Y 0.02055f
C7 A VPB 0.03373f
C8 A Y 0
C9 S B 0.09717f
C10 VPWR VGND 0.02231f
C11 VPB S 0.09704f
C12 VPB B 0.06569f
C13 S Y 0.00438f
C14 B Y 0.01119f
C15 A VGND 0.01542f
C16 A VPWR 0.01566f
C17 VPB Y 0.02103f
C18 S VGND 0.04425f
C19 VPWR S 0.0493f
C20 VGND VNB 0.0148f
C21 Y VNB 0f
C22 VPWR VNB 0.20077f
C23 S VNB 0.01563f
C24 B VNB 0f
C25 A VNB 0.05065f
C26 VPB VNB 0.54388f
C27 a_63_47.t1 VNB 0.13193f
C28 a_63_47.n0 VNB 0.18178f
C29 a_63_47.t2 VNB 0.05708f
C30 a_63_47.n1 VNB 0.23031f
C31 a_63_47.n2 VNB 0.03343f
C32 a_63_47.t0 VNB 0.03838f
C33 a_63_47.t3 VNB 0.03243f
C34 a_63_47.n3 VNB 0.07677f
C35 a_145_297.t0 VNB 0.04856f
C36 a_145_297.t1 VNB 0.04354f
C37 a_245_297.t0 VNB 0.04971f
C38 a_245_297.t1 VNB 0.04219f
C39 a_451_297.t0 VNB 0.03802f
C40 a_451_297.n0 VNB 0.11646f
C41 a_451_297.t2 VNB 0.15498f
C42 a_451_297.t1 VNB 0.04628f
C43 a_533_47.t0 VNB 0.03549f
C44 a_533_47.t1 VNB 0.02954f
C45 VPB.t0 VNB 0.10254f
C46 VPB.t1 VNB 0.04883f
C47 VPB.t2 VNB 0.04395f
C48 VPB.t3 VNB 0.04907f
C49 VPB.t4 VNB 0.07031f
C50 VPB.t5 VNB 0.06934f
C51 A.n0 VNB 0.05117f
C52 B.n0 VNB 0.06075f
C53 B.n1 VNB 0.08363f
C54 B.n2 VNB 0.06128f
C55 B.n3 VNB 0.13388f
C56 S.n0 VNB 0.08306f
C57 S.n1 VNB 0.09514f
C58 VPWR.n0 VNB 0.24178f
C59 VPWR.t1 VNB 0.06691f
C60 VPWR.t0 VNB 0.03601f
C61 VPWR.t2 VNB 0.04352f
C62 VPWR.n1 VNB 0.02723f
C63 Y.n0 VNB 0.02331f
C64 Y.t2 VNB 0.03335f
C65 Y.t1 VNB 0.02738f
C66 Y.n1 VNB 0.04072f
C67 Y.t0 VNB 0.08618f
C68 Y.n2 VNB 0.06673f
C69 Y.n3 VNB 0.02505f
C70 VGND.n0 VNB 0.00738f
C71 VGND.n1 VNB 0.0311f
C72 VGND.n2 VNB 0.00957f
C73 VGND.n3 VNB 0.02701f
C74 VGND.n4 VNB 0.0053f
C75 VGND.n5 VNB 0.08541f
C76 VGND.n6 VNB 0.09553f
C77 VGND.n7 VNB 0.03327f
C78 VGND.t3 VNB 0.03595f
C79 VGND.n8 VNB 0.03459f
C80 VGND.t1 VNB 0.03169f
C81 VGND.t0 VNB 0.03169f
C82 VGND.n9 VNB 0.02032f
C83 VGND.t2 VNB 0.02526f
C84 VGND.t4 VNB 0.02889f
C85 VGND.n10 VNB 0.01461f
C86 VGND.n11 VNB 0.01659f
.ends
