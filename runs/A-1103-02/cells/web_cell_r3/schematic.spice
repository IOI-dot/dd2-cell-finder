.subckt web_cell_r3 A B S VGND VNB VPB VPWR Y
X0 _s1 A VGND VNB sky130_fd_pr__nfet_01v8 w=650000u l=150000u
X1 _s1 B VGND VNB sky130_fd_pr__nfet_01v8 w=650000u l=150000u
X2 _s1 S VGND VNB sky130_fd_pr__nfet_01v8 w=650000u l=150000u
X3 Y _s1 VGND VNB sky130_fd_pr__nfet_01v8 w=650000u l=150000u
X4 Y B n1 VNB sky130_fd_pr__nfet_01v8 w=650000u l=150000u
X5 n1 S VGND VNB sky130_fd_pr__nfet_01v8 w=650000u l=150000u
X6 _s1 A p1 VPB sky130_fd_pr__pfet_01v8_hvt w=1000000u l=150000u
X7 p1 B p2 VPB sky130_fd_pr__pfet_01v8_hvt w=1000000u l=150000u
X8 p2 S VPWR VPB sky130_fd_pr__pfet_01v8_hvt w=1000000u l=150000u
X9 Y _s1 p3 VPB sky130_fd_pr__pfet_01v8_hvt w=1000000u l=150000u
X10 p3 B VPWR VPB sky130_fd_pr__pfet_01v8_hvt w=1000000u l=150000u
X11 p3 S VPWR VPB sky130_fd_pr__pfet_01v8_hvt w=1000000u l=150000u
.ends
