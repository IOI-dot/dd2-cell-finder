* NGSPICE file created from web_cell_r3.ext - technology: sky130A

.subckt web_cell_r3 A B S VGND VNB VPB VPWR Y
X0 a_145_297.t0 a_91_199.t5 Y.t1 VPB.t0 sky130_fd_pr__pfet_01v8_hvt ad=0.175 pd=1.35 as=0.26 ps=2.52 w=1 l=0.15 sa=0.26 sb=1.26
X1 a_245_47.t0 B.t1 Y.t0 VNB.t1 sky130_fd_pr__nfet_01v8 ad=0.11375 pd=1 as=0.11375 ps=1 w=0.65 l=0.15 sa=0.76 sb=2.6
X2 a_91_199.t3 S.t0 VGND.t1 VNB.t5 sky130_fd_pr__nfet_01v8 ad=0.10725 pd=0.98 as=0.25675 ps=1.44 w=0.65 l=0.15 sa=2.2 sb=1.16
X3 a_91_199.t1 A.t1 a_629_297.t1 VPB.t3 sky130_fd_pr__pfet_01v8_hvt ad=0.26 pd=2.52 as=0.135 ps=1.27 w=1 l=0.15 sa=1.16 sb=0.26
X4 a_145_297.t2 S.t3 VPWR.t1 VPB.t4 sky130_fd_pr__pfet_01v8_hvt ad=0.26 pd=2.52 as=0.175 ps=1.35 w=1 l=0.15 sa=1.26 sb=0.26
X5 Y.t2 a_91_199.t4 VGND.t4 VNB.t0 sky130_fd_pr__nfet_01v8 ad=0.11375 pd=1 as=0.169 ps=1.82 w=0.65 l=0.15 sa=0.26 sb=3.1
X6 a_91_199.t2 A.t0 VGND.t0 VNB.t3 sky130_fd_pr__nfet_01v8 ad=0.169 pd=1.82 as=0.08775 ps=0.92 w=0.65 l=0.15 sa=3.1 sb=0.26
X7 a_629_297.t0 B.t2 a_533_297.t0 VPB.t2 sky130_fd_pr__pfet_01v8_hvt ad=0.135 pd=1.27 as=0.165 ps=1.33 w=1 l=0.15 sa=0.74 sb=0.68
X8 VGND.t3 B.t0 a_91_199.t0 VNB.t2 sky130_fd_pr__nfet_01v8 ad=0.08775 pd=0.92 as=0.10725 ps=0.98 w=0.65 l=0.15 sa=2.68 sb=0.68
X9 VPWR.t2 B.t3 a_145_297.t1 VPB.t1 sky130_fd_pr__pfet_01v8_hvt ad=0.175 pd=1.35 as=0.175 ps=1.35 w=1 l=0.15 sa=0.76 sb=0.76
X10 a_533_297.t1 S.t2 VPWR.t0 VPB.t5 sky130_fd_pr__pfet_01v8_hvt ad=0.165 pd=1.33 as=0.26 ps=2.52 w=1 l=0.15 sa=0.26 sb=1.16
X11 VGND.t2 S.t1 a_245_47.t1 VNB.t4 sky130_fd_pr__nfet_01v8 ad=0.25675 pd=1.44 as=0.11375 ps=1 w=0.65 l=0.15 sa=1.26 sb=2.1
R0 VGND.n1 VGND.n0 9.3005
R1 VGND.n3 VGND.n2 9.3005
R2 VGND.n5 VGND.n4 9.3005
R3 VGND.n7 VGND.n6 9.3005
R4 VGND VGND.n13 0.0226354
R5 VGND.n13 VGND.n1 0.120292
R6 VGND.n1 VGND.n3 0.120292
R7 VGND.n3 VGND.n5 0.120292
R8 VGND.n5 VGND.n7 0.120292
R9 VGND.n7 VGND.n8 0.80874
R10 VGND.n8 VGND.n9 218.76
R11 VGND.n13 VGND.n12 25.1123
R12 VGND.n12 VGND.n0 18.824
R13 VGND.n0 VGND.n2 34.6358
R14 VGND.n2 VGND.n4 34.6358
R15 VGND.n4 VGND.n6 34.6358
R16 VGND.n6 VGND.n11 3.76521
R17 VGND.n11 VGND.n8 37.8102
R18 VGND.n12 VGND.t4 290.289
R19 VGND.n11 VGND.n10 120.698
R20 VGND.n10 VGND.t2 72.9236
R21 VGND.n10 VGND.t1 72.9236
R22 VGND.n9 VGND.t3 24.9236
R23 VGND.n9 VGND.t0 24.9236
R24 VPWR VPWR.n0 0.652651
R25 VPWR.n0 VPWR.t0 269.098
R26 VPWR.n0 VPWR.n1 619.26
R27 VPWR.n1 VPWR.t2 34.4755
R28 VPWR.n1 VPWR.t1 34.4755
R29 Y.n0 Y.n1 185
R30 Y.n3 Y.n0 197.8
R31 Y.n3 Y 6.4005
R32 Y Y.n1 6.4005
R33 Y Y.n3 2.25932
R34 Y.n1 Y.n2 106.918
R35 Y Y.n2 3.29747
R36 Y.n2 Y.t1 228.772
R37 Y.n0 Y.t2 32.3082
R38 Y.n0 Y.t0 32.3082
R39 A A.n0 158.4
R40 A.n0 A.t0 169.237
R41 A.n0 A.t1 241.536
R42 S S.n1 167.165
R43 S.n1 S.n0 137.298
R44 S.n1 S.t3 212.081
R45 S.n1 S.t1 139.78
R46 S.n0 S.t2 212.081
R47 S.n0 S.t0 139.78
R48 B.n1 B.n0 152
R49 B B.n1 6.4005
R50 B.n3 B.n1 25.5806
R51 B B.n3 0.376971
R52 B.n3 B.n2 158.024
R53 B.n2 B.t0 169.237
R54 B.n2 B.t2 241.536
R55 B.n0 B.t1 169.237
R56 B.n0 B.t3 241.536
R57 VPB VPB.t0 298.911
R58 VPB.t0 VPB.t1 295.95
R59 VPB.t1 VPB.t4 295.95
R60 VPB.t4 VPB.t5 556.386
R61 VPB.t5 VPB.t2 284.113
R62 VPB.t2 VPB.t3 248.599
R63 VNB VNB.t0 1438.19
R64 VNB.t0 VNB.t1 1423.95
R65 VNB.t1 VNB.t4 1423.95
R66 VNB.t4 VNB.t5 2677.02
R67 VNB.t5 VNB.t2 1366.99
R68 VNB.t2 VNB.t3 1196.12
R69 a_245_47.t0 a_245_47.t1 64.6159
R70 a_629_297.t0 a_629_297.t1 53.1905
R71 a_533_297.t0 a_533_297.t1 65.0105
R72 a_145_297.n0 a_145_297.t2 585.855
R73 a_145_297.t0 a_145_297.n0 34.4755
R74 a_145_297.n0 a_145_297.t1 34.4755
R75 a_91_199.t1 a_91_199.n0 320.949
R76 a_91_199.n1 a_91_199.n2 92.501
R77 a_91_199.n0 a_91_199.n1 61.8919
R78 a_91_199.n1 a_91_199.n3 197.921
R79 a_91_199.n3 a_91_199.t4 169.237
R80 a_91_199.n3 a_91_199.t5 241.536
R81 a_91_199.n2 a_91_199.t3 30.462
R82 a_91_199.n2 a_91_199.t0 30.462
R83 a_91_199.n0 a_91_199.t2 131.8
C0 B S 0.09717f
C1 VPB B 0.06563f
C2 Y S 0.00392f
C3 Y VPB 0.02307f
C4 VGND S 0.04687f
C5 VGND VPB 0.01235f
C6 A B 0.03457f
C7 VPWR B 0.07958f
C8 Y A 0
C9 VGND A 0.01547f
C10 VPWR Y 0.03789f
C11 VPB S 0.0944f
C12 VGND VPWR 0.02378f
C13 A VPB 0.03257f
C14 VPWR S 0.04687f
C15 VPWR VPB 0.14163f
C16 Y B 0.01516f
C17 VGND B 0.03773f
C18 VGND Y 0.0694f
C19 VPWR A 0.01583f
C20 VGND VNB 0f
C21 VPWR VNB 0.21336f
C22 Y VNB 0f
C23 A VNB 0.05048f
C24 S VNB 0.01756f
C25 B VNB 0f
C26 VPB VNB 0.54073f
C27 a_91_199.t1 VNB 0.13306f
C28 a_91_199.n0 VNB 0.18141f
C29 a_91_199.t2 VNB 0.05749f
C30 a_91_199.n1 VNB 0.23568f
C31 a_91_199.n2 VNB 0.03188f
C32 a_91_199.t3 VNB 0.03155f
C33 a_91_199.t0 VNB 0.03785f
C34 a_91_199.n3 VNB 0.07852f
C35 a_145_297.t0 VNB 0.04268f
C36 a_145_297.n0 VNB 0.09291f
C37 a_145_297.t2 VNB 0.15086f
C38 a_145_297.t1 VNB 0.05105f
C39 a_533_297.t0 VNB 0.04913f
C40 a_533_297.t1 VNB 0.04112f
C41 a_629_297.t0 VNB 0.04461f
C42 a_629_297.t1 VNB 0.03925f
C43 a_245_47.t0 VNB 0.03648f
C44 a_245_47.t1 VNB 0.03018f
C45 VPB.t0 VNB 0.04955f
C46 VPB.t1 VNB 0.0493f
C47 VPB.t2 VNB 0.04437f
C48 VPB.t3 VNB 0.10353f
C49 VPB.t4 VNB 0.07099f
C50 VPB.t5 VNB 0.07001f
C51 B.n0 VNB 0.06143f
C52 B.n1 VNB 0.08457f
C53 B.n2 VNB 0.06197f
C54 B.n3 VNB 0.13539f
C55 S.n0 VNB 0.0825f
C56 S.n1 VNB 0.0945f
C57 A.n0 VNB 0.05119f
C58 Y.n0 VNB 0.02752f
C59 Y.t2 VNB 0.02967f
C60 Y.t0 VNB 0.03572f
C61 Y.n1 VNB 0.03583f
C62 Y.n2 VNB 0.10029f
C63 Y.t1 VNB 0.08101f
C64 Y.n3 VNB 0.03648f
C65 VPWR.n0 VNB 0.2334f
C66 VPWR.t2 VNB 0.04462f
C67 VPWR.t1 VNB 0.03661f
C68 VPWR.n1 VNB 0.02867f
C69 VPWR.t0 VNB 0.06677f
C70 VGND.n0 VNB 0.00751f
C71 VGND.n1 VNB 0.02747f
C72 VGND.n2 VNB 0.00973f
C73 VGND.n3 VNB 0.02747f
C74 VGND.n4 VNB 0.00973f
C75 VGND.n5 VNB 0.02747f
C76 VGND.n6 VNB 0.00539f
C77 VGND.n7 VNB 0.12933f
C78 VGND.n8 VNB 0.05252f
C79 VGND.t3 VNB 0.02764f
C80 VGND.t0 VNB 0.02377f
C81 VGND.n9 VNB 0.01269f
C82 VGND.n10 VNB 0.03518f
C83 VGND.t2 VNB 0.03185f
C84 VGND.t1 VNB 0.03185f
C85 VGND.n11 VNB 0.02038f
C86 VGND.t4 VNB 0.03549f
C87 VGND.n12 VNB 0.01889f
C88 VGND.n13 VNB 0.02073f
.ends
