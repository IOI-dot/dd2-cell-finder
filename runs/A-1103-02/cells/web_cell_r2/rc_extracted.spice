* NGSPICE file created from web_cell_r2.ext - technology: sky130A

.subckt web_cell_r2 A B S Y VGND VPWR VPB VNB Y_uq0
X0 VPWR.t1 S.t3 a_304_297.t1 VPB.t4 sky130_fd_pr__pfet_01v8_hvt ad=0.26 pd=2.52 as=0.135 ps=1.27 w=1 l=0.15
X1 a_304_297.t0 B.t3 a_114_297.t1 VPB.t2 sky130_fd_pr__pfet_01v8_hvt ad=0.135 pd=1.27 as=0.4 ps=1.8 w=1 l=0.15
X2 a_707_47.t0 B.t0 Y_uq0.t1 VNB.t3 sky130_fd_pr__nfet_01v8 ad=0.16087 pd=1.145 as=0.16087 ps=1.145 w=0.65 l=0.15
X3 VGND.t4 A.t0 a_32_47.t1 VNB.t0 sky130_fd_pr__nfet_01v8 ad=0.26 pd=1.45 as=0.169 ps=1.82 w=0.65 l=0.15
X4 a_32_47.t2 B.t1 VGND.t3 VNB.t2 sky130_fd_pr__nfet_01v8 ad=0.08775 pd=0.92 as=0.26 ps=1.45 w=0.65 l=0.15
X5 VPWR.t2 B.t2 a_578_297.t1 VPB.t3 sky130_fd_pr__pfet_01v8_hvt ad=0.2475 pd=1.495 as=0.2475 ps=1.495 w=1 l=0.15
X6 a_578_297.t2 S.t2 VPWR.t0 VPB.t5 sky130_fd_pr__pfet_01v8_hvt ad=0.26 pd=2.52 as=0.2475 ps=1.495 w=1 l=0.15
X7 VGND.t1 S.t0 a_707_47.t1 VNB.t5 sky130_fd_pr__nfet_01v8 ad=0.169 pd=1.82 as=0.16087 ps=1.145 w=0.65 l=0.15
X8 VGND.t2 S.t1 a_32_47.t3 VNB.t4 sky130_fd_pr__nfet_01v8 ad=0.26 pd=1.45 as=0.08775 ps=0.92 w=0.65 l=0.15
X9 a_578_297.t0 a_32_47.t5 Y.t0 VPB.t1 sky130_fd_pr__pfet_01v8_hvt ad=0.2475 pd=1.495 as=0.26 ps=2.52 w=1 l=0.15
X10 a_114_297.t0 A.t1 a_32_47.t0 VPB.t0 sky130_fd_pr__pfet_01v8_hvt ad=0.4 pd=1.8 as=0.26 ps=2.52 w=1 l=0.15
X11 Y_uq0.t0 a_32_47.t4 VGND.t0 VNB.t1 sky130_fd_pr__nfet_01v8 ad=0.16087 pd=1.145 as=0.26 ps=1.45 w=0.65 l=0.15
R0 Y_uq0 Y_uq0.n0 191.4
R1 Y_uq0.n0 Y_uq0.t0 45.2313
R2 Y_uq0.n0 Y_uq0.t1 46.1543
R3 VGND.n1 VGND.n0 9.3005
R4 VGND.n3 VGND.n2 9.3005
R5 VGND.n5 VGND.n4 9.3005
R6 VGND VGND.n7 0.121778
R7 VGND.n7 VGND.n1 0.141672
R8 VGND.n1 VGND.n3 0.120292
R9 VGND.n3 VGND.n5 0.120292
R10 VGND.n5 VGND.n6 0.160791
R11 VGND.n6 VGND.t1 170.534
R12 VGND.n7 VGND.n11 28.7414
R13 VGND.n0 VGND.n11 13.5534
R14 VGND.n0 VGND.n2 34.6358
R15 VGND.n2 VGND.n4 34.6358
R16 VGND.n4 VGND.n9 20.3299
R17 VGND.n6 VGND.n9 21.8934
R18 VGND.n11 VGND.n10 207.213
R19 VGND.n10 VGND.t4 73.8467
R20 VGND.n10 VGND.t3 73.8467
R21 VGND.n9 VGND.n8 207.213
R22 VGND.n8 VGND.t2 73.8467
R23 VGND.n8 VGND.t0 73.8467
R24 Y Y.t0 860.381
R25 VPWR VPWR.n0 0.521835
R26 VPWR.n0 VPWR.n1 618.947
R27 VPWR.n1 VPWR.t2 48.2655
R28 VPWR.n1 VPWR.t0 49.2505
R29 VPWR.n0 VPWR.t1 882.855
R30 S.n1 S.n0 152
R31 S S.n1 6.4005
R32 S.n3 S.n1 154.353
R33 S S.n3 0.376971
R34 S.n3 S.n2 158.024
R35 S.n2 S.t0 158.064
R36 S.n2 S.t2 230.363
R37 S.n0 S.t1 158.064
R38 S.n0 S.t3 230.363
R39 B.n1 B.n0 152
R40 B B.n1 3.29747
R41 B.n3 B.n2 152
R42 B B.n3 3.29747
R43 B.n3 B.n1 210.266
R44 B.n2 B.t0 158.064
R45 B.n2 B.t2 230.363
R46 B.n0 B.t1 158.064
R47 B.n0 B.t3 230.363
R48 A A.n0 158.4
R49 A.n0 A.t0 158.064
R50 A.n0 A.t1 230.363
R51 VPB VPB.t0 207.166
R52 VPB.t0 VPB.t2 562.306
R53 VPB.t2 VPB.t4 248.599
R54 VPB.t4 VPB.t1 562.306
R55 VPB.t1 VPB.t3 381.776
R56 VPB.t3 VPB.t5 381.776
R57 VNB VNB.t0 996.764
R58 VNB.t0 VNB.t2 2705.5
R59 VNB.t2 VNB.t4 1196.12
R60 VNB.t4 VNB.t1 2705.5
R61 VNB.t1 VNB.t3 1836.89
R62 VNB.t3 VNB.t5 1836.89
R63 a_707_47.t0 a_707_47.t1 91.3851
R64 a_578_297.t0 a_578_297.n0 48.2655
R65 a_578_297.n0 a_578_297.t1 49.2505
R66 a_578_297.n0 a_578_297.t2 903.064
R67 a_304_297.t0 a_304_297.t1 53.1905
R68 a_114_297.t0 a_114_297.t1 157.601
R69 a_32_47.t0 a_32_47.n3 288.652
R70 a_32_47.n3 a_32_47.n2 78.3064
R71 a_32_47.n2 a_32_47.n0 100.296
R72 a_32_47.n2 a_32_47.n1 275.356
R73 a_32_47.n1 a_32_47.t4 158.064
R74 a_32_47.n1 a_32_47.t5 230.363
R75 a_32_47.n0 a_32_47.t2 24.9236
R76 a_32_47.n0 a_32_47.t3 24.9236
R77 a_32_47.n3 a_32_47.t1 140.367
C0 VGND VPWR 0.05219f
C1 Y_uq0 VGND 0.03561f
C2 B VPWR 0.08366f
C3 A VPWR 0.01763f
C4 Y_uq0 B 0.00189f
C5 VPB Y 0.00343f
C6 VPB S 0.0817f
C7 VGND Y 0.00148f
C8 VGND S 0.10767f
C9 VPB VGND 0.01058f
C10 Y_uq0 VPWR 0.00148f
C11 B Y 0.018f
C12 S B 0.1022f
C13 VPB B 0.0979f
C14 VPB A 0.04622f
C15 VGND B 0.03585f
C16 VGND A 0.01578f
C17 VPWR Y 0.02828f
C18 S VPWR 0.0391f
C19 Y_uq0 S 0.0199f
C20 VPB VPWR 0.12689f
C21 B A 0.02709f
C22 Y_uq0 VNB 0.01121f
C23 VGND VNB 0.60201f
C24 Y VNB 0.01712f
C25 VPWR VNB 0.54501f
C26 S VNB 0.21979f
C27 B VNB 0.17185f
C28 A VNB 0.1217f
C29 VPB VNB 1.00498f
C30 a_32_47.t0 VNB 0.11526f
C31 a_32_47.t1 VNB 0.0587f
C32 a_32_47.n0 VNB 0.02839f
C33 a_32_47.t2 VNB 0.03374f
C34 a_32_47.t3 VNB 0.03203f
C35 a_32_47.n1 VNB 0.08571f
C36 a_32_47.n2 VNB 0.14707f
C37 a_32_47.n3 VNB 0.18042f
C38 a_114_297.t0 VNB 0.06448f
C39 a_114_297.t1 VNB 0.06928f
C40 a_304_297.t0 VNB 0.04271f
C41 a_304_297.t1 VNB 0.04035f
C42 a_578_297.t0 VNB 0.04431f
C43 a_578_297.n0 VNB 0.07637f
C44 a_578_297.t2 VNB 0.14977f
C45 a_578_297.t1 VNB 0.05301f
C46 a_707_47.t0 VNB 0.03843f
C47 a_707_47.t1 VNB 0.03672f
C48 VPB.t0 VNB 0.05841f
C49 VPB.t1 VNB 0.07166f
C50 VPB.t2 VNB 0.06155f
C51 VPB.t3 VNB 0.05796f
C52 VPB.t4 VNB 0.06155f
C53 VPB.t5 VNB 0.09053f
C54 A.n0 VNB 0.06972f
C55 B.n0 VNB 0.08269f
C56 B.n1 VNB 0.11396f
C57 B.n2 VNB 0.08269f
C58 B.n3 VNB 0.12197f
C59 S.n0 VNB 0.07609f
C60 S.n1 VNB 0.07549f
C61 S.n2 VNB 0.07657f
C62 S.n3 VNB 0.08318f
C63 VPWR.n0 VNB 0.34916f
C64 VPWR.t1 VNB 0.06207f
C65 VPWR.t2 VNB 0.04757f
C66 VPWR.t0 VNB 0.04557f
C67 VPWR.n1 VNB 0.03724f
C68 Y.t0 VNB 0.07015f
C69 VGND.n0 VNB 0.00552f
C70 VGND.n1 VNB 0.02581f
C71 VGND.n2 VNB 0.00794f
C72 VGND.n3 VNB 0.02241f
C73 VGND.n4 VNB 0.0063f
C74 VGND.n5 VNB 0.03677f
C75 VGND.n6 VNB 0.14584f
C76 VGND.n7 VNB 0.0285f
C77 VGND.t1 VNB 0.03729f
C78 VGND.t2 VNB 0.03282f
C79 VGND.t0 VNB 0.02858f
C80 VGND.n8 VNB 0.02697f
C81 VGND.n9 VNB 0.01386f
C82 VGND.t4 VNB 0.03106f
C83 VGND.t3 VNB 0.03452f
C84 VGND.n10 VNB 0.02697f
C85 VGND.n11 VNB 0.01348f
C86 Y_uq0.t0 VNB 0.02873f
C87 Y_uq0.t1 VNB 0.03494f
C88 Y_uq0.n0 VNB 0.02716f
.ends
