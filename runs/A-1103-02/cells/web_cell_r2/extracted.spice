* NGSPICE file created from web_cell_r2.ext - technology: sky130A

.subckt web_cell_r2 A B S Y VGND VPWR VPB VNB Y_uq0
X0 VPWR S a_304_297# VPB sky130_fd_pr__pfet_01v8_hvt ad=0.26 pd=2.52 as=0.135 ps=1.27 w=1 l=0.15
X1 a_304_297# B a_114_297# VPB sky130_fd_pr__pfet_01v8_hvt ad=0.135 pd=1.27 as=0.4 ps=1.8 w=1 l=0.15
X2 a_707_47# B Y_uq0 VNB sky130_fd_pr__nfet_01v8 ad=0.16087 pd=1.145 as=0.16087 ps=1.145 w=0.65 l=0.15
X3 VGND A a_32_47# VNB sky130_fd_pr__nfet_01v8 ad=0.26 pd=1.45 as=0.169 ps=1.82 w=0.65 l=0.15
X4 a_32_47# B VGND VNB sky130_fd_pr__nfet_01v8 ad=0.08775 pd=0.92 as=0.26 ps=1.45 w=0.65 l=0.15
X5 VPWR B a_578_297# VPB sky130_fd_pr__pfet_01v8_hvt ad=0.2475 pd=1.495 as=0.2475 ps=1.495 w=1 l=0.15
X6 a_578_297# S VPWR VPB sky130_fd_pr__pfet_01v8_hvt ad=0.26 pd=2.52 as=0.2475 ps=1.495 w=1 l=0.15
X7 VGND S a_707_47# VNB sky130_fd_pr__nfet_01v8 ad=0.169 pd=1.82 as=0.16087 ps=1.145 w=0.65 l=0.15
X8 VGND S a_32_47# VNB sky130_fd_pr__nfet_01v8 ad=0.26 pd=1.45 as=0.08775 ps=0.92 w=0.65 l=0.15
X9 a_578_297# a_32_47# Y VPB sky130_fd_pr__pfet_01v8_hvt ad=0.2475 pd=1.495 as=0.26 ps=2.52 w=1 l=0.15
X10 a_114_297# A a_32_47# VPB sky130_fd_pr__pfet_01v8_hvt ad=0.4 pd=1.8 as=0.26 ps=2.52 w=1 l=0.15
X11 Y_uq0 a_32_47# VGND VNB sky130_fd_pr__nfet_01v8 ad=0.16087 pd=1.145 as=0.26 ps=1.45 w=0.65 l=0.15
.ends
