* NGSPICE file created from web_cell_r1.ext - technology: sky130A

.subckt web_cell_r1 A B S VGND VNB VPB VPWR Y
X0 a_286_199# A a_751_297# VPB sky130_fd_pr__pfet_01v8_hvt ad=0.26 pd=2.52 as=0.135 ps=1.27 w=1 l=0.15
X1 a_115_47# S VGND VNB sky130_fd_pr__nfet_01v8 ad=0.16087 pd=1.145 as=0.169 ps=1.82 w=0.65 l=0.15
X2 Y B a_115_47# VNB sky130_fd_pr__nfet_01v8 ad=0.16087 pd=1.145 as=0.16087 ps=1.145 w=0.65 l=0.15
X3 VGND B a_286_199# VNB sky130_fd_pr__nfet_01v8 ad=0.08775 pd=0.92 as=0.26 ps=1.45 w=0.65 l=0.15
X4 a_751_297# B a_561_297# VPB sky130_fd_pr__pfet_01v8_hvt ad=0.135 pd=1.27 as=0.4 ps=1.8 w=1 l=0.15
X5 Y a_286_199# a_33_297# VPB sky130_fd_pr__pfet_01v8_hvt ad=0.26 pd=2.52 as=0.2475 ps=1.495 w=1 l=0.15
X6 a_286_199# A VGND VNB sky130_fd_pr__nfet_01v8 ad=0.169 pd=1.82 as=0.08775 ps=0.92 w=0.65 l=0.15
X7 VGND a_286_199# Y VNB sky130_fd_pr__nfet_01v8 ad=0.25675 pd=1.44 as=0.16087 ps=1.145 w=0.65 l=0.15
X8 a_33_297# B VPWR VPB sky130_fd_pr__pfet_01v8_hvt ad=0.2475 pd=1.495 as=0.2475 ps=1.495 w=1 l=0.15
X9 a_561_297# S VPWR VPB sky130_fd_pr__pfet_01v8_hvt ad=0.4 pd=1.8 as=0.26 ps=2.52 w=1 l=0.15
X10 VPWR S a_33_297# VPB sky130_fd_pr__pfet_01v8_hvt ad=0.2475 pd=1.495 as=0.26 ps=2.52 w=1 l=0.15
X11 a_286_199# S VGND VNB sky130_fd_pr__nfet_01v8 ad=0.26 pd=1.45 as=0.25675 ps=1.44 w=0.65 l=0.15
.ends
