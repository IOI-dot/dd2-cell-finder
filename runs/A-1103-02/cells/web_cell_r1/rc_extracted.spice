* NGSPICE file created from web_cell_r1.ext - technology: sky130A

.subckt web_cell_r1 A B S VGND VNB VPB VPWR Y
X0 a_286_199.t1 A.t1 a_751_297.t0 VPB.t3 sky130_fd_pr__pfet_01v8_hvt ad=0.26 pd=2.52 as=0.135 ps=1.27 w=1 l=0.15 sa=1.63 sb=0.26
X1 a_115_47.t0 S.t1 VGND.t3 VNB.t1 sky130_fd_pr__nfet_01v8 ad=0.16087 pd=1.145 as=0.169 ps=1.82 w=0.65 l=0.15 sa=0.26 sb=3.86
X2 Y.t0 B.t1 a_115_47.t1 VNB.t4 sky130_fd_pr__nfet_01v8 ad=0.16087 pd=1.145 as=0.16087 ps=1.145 w=0.65 l=0.15 sa=0.905 sb=3.215
X3 VGND.t1 B.t0 a_286_199.t3 VNB.t5 sky130_fd_pr__nfet_01v8 ad=0.08775 pd=0.92 as=0.26 ps=1.45 w=0.65 l=0.15 sa=3.44 sb=0.68
X4 a_751_297.t1 B.t2 a_561_297.t1 VPB.t5 sky130_fd_pr__pfet_01v8_hvt ad=0.135 pd=1.27 as=0.4 ps=1.8 w=1 l=0.15 sa=1.21 sb=0.68
X5 Y.t2 a_286_199.t5 a_33_297.t0 VPB.t0 sky130_fd_pr__pfet_01v8_hvt ad=0.26 pd=2.52 as=0.2475 ps=1.495 w=1 l=0.15 sa=1.55 sb=0.26
X6 a_286_199.t2 A.t0 VGND.t0 VNB.t3 sky130_fd_pr__nfet_01v8 ad=0.169 pd=1.82 as=0.08775 ps=0.92 w=0.65 l=0.15 sa=3.86 sb=0.26
X7 VGND.t4 a_286_199.t4 Y.t1 VNB.t0 sky130_fd_pr__nfet_01v8 ad=0.25675 pd=1.44 as=0.16087 ps=1.145 w=0.65 l=0.15 sa=1.55 sb=2.57
X8 a_33_297.t2 B.t3 VPWR.t0 VPB.t4 sky130_fd_pr__pfet_01v8_hvt ad=0.2475 pd=1.495 as=0.2475 ps=1.495 w=1 l=0.15 sa=0.905 sb=0.905
X9 a_561_297.t0 S.t2 VPWR.t1 VPB.t2 sky130_fd_pr__pfet_01v8_hvt ad=0.4 pd=1.8 as=0.26 ps=2.52 w=1 l=0.15 sa=0.26 sb=1.63
X10 VPWR.t2 S.t3 a_33_297.t1 VPB.t1 sky130_fd_pr__pfet_01v8_hvt ad=0.2475 pd=1.495 as=0.26 ps=2.52 w=1 l=0.15 sa=0.26 sb=1.55
X11 a_286_199.t0 S.t0 VGND.t2 VNB.t2 sky130_fd_pr__nfet_01v8 ad=0.26 pd=1.45 as=0.25675 ps=1.44 w=0.65 l=0.15 sa=2.49 sb=1.63
R0 VGND.n1 VGND.n0 9.3005
R1 VGND.n3 VGND.n2 9.3005
R2 VGND.n5 VGND.n4 9.3005
R3 VGND.n7 VGND.n6 9.3005
R4 VGND VGND.n13 0.0226354
R5 VGND.n13 VGND.n1 0.120292
R6 VGND.n1 VGND.n3 0.120292
R7 VGND.n3 VGND.n5 0.120292
R8 VGND.n5 VGND.n7 0.120292
R9 VGND.n7 VGND.n8 0.200491
R10 VGND.n8 VGND.n9 214.94
R11 VGND.n13 VGND.n12 13.8181
R12 VGND.n12 VGND.n0 30.1181
R13 VGND.n0 VGND.n2 34.6358
R14 VGND.n2 VGND.n4 34.6358
R15 VGND.n4 VGND.n6 34.6358
R16 VGND.n6 VGND.n11 14.3064
R17 VGND.n11 VGND.n8 27.8772
R18 VGND.n12 VGND.t3 290.289
R19 VGND.n11 VGND.n10 207.213
R20 VGND.n10 VGND.t4 72.9236
R21 VGND.n10 VGND.t2 72.9236
R22 VGND.n9 VGND.t1 24.9236
R23 VGND.n9 VGND.t0 24.9236
R24 Y.n1 Y.n0 185
R25 Y Y.n1 6.4005
R26 Y.n2 Y.n1 25.2653
R27 Y.n2 Y.t2 228.772
R28 Y Y.n2 3.29747
R29 Y.n0 Y.t0 45.2313
R30 Y.n0 Y.t1 46.1543
R31 VPWR VPWR.n0 0.19944
R32 VPWR.n0 VPWR.t1 883.544
R33 VPWR.n0 VPWR.n1 618.614
R34 VPWR.n1 VPWR.t2 49.2505
R35 VPWR.n1 VPWR.t0 48.2655
R36 A A.n0 158.4
R37 A.n0 A.t0 158.064
R38 A.n0 A.t1 230.363
R39 B.n1 B.n0 152
R40 B B.n1 6.4005
R41 B.n3 B.n1 26.7354
R42 B B.n3 0.376971
R43 B.n3 B.n2 158.024
R44 B.n2 B.t0 158.064
R45 B.n2 B.t2 230.363
R46 B.n0 B.t1 158.064
R47 B.n0 B.t3 230.363
R48 S.n1 S.n0 152
R49 S S.n1 6.4005
R50 S S.n1 258.635
R51 S S.n2 158.4
R52 S.n2 S.t0 158.064
R53 S.n2 S.t2 230.363
R54 S.n0 S.t1 158.064
R55 S.n0 S.t3 230.363
R56 VPB VPB.t1 210.125
R57 VPB.t1 VPB.t4 381.776
R58 VPB.t4 VPB.t0 381.776
R59 VPB.t0 VPB.t2 556.386
R60 VPB.t2 VPB.t5 562.306
R61 VPB.t5 VPB.t3 248.599
R62 VNB VNB.t1 1011
R63 VNB.t1 VNB.t4 1836.89
R64 VNB.t4 VNB.t0 1836.89
R65 VNB.t0 VNB.t2 2677.02
R66 VNB.t2 VNB.t5 2705.5
R67 VNB.t5 VNB.t3 1196.12
R68 a_115_47.t0 a_115_47.t1 91.3851
R69 a_751_297.t0 a_751_297.t1 53.1905
R70 a_561_297.t0 a_561_297.t1 157.601
R71 a_33_297.n0 a_33_297.t2 48.2655
R72 a_33_297.t0 a_33_297.n0 49.2505
R73 a_33_297.n0 a_33_297.t1 494.57
R74 a_286_199.t1 a_286_199.n3 246.844
R75 a_286_199.n3 a_286_199.n2 51.9534
R76 a_286_199.n2 a_286_199.t2 160.6
R77 a_286_199.n2 a_286_199.n1 143.287
R78 a_286_199.n1 a_286_199.t0 73.8467
R79 a_286_199.n1 a_286_199.t3 73.8467
R80 a_286_199.n3 a_286_199.n0 353.036
R81 a_286_199.n0 a_286_199.t4 158.064
R82 a_286_199.n0 a_286_199.t5 230.363
C0 S B 0.11591f
C1 VPB S 0.08727f
C2 VPWR B 0.15322f
C3 VPWR VPB 0.12511f
C4 VGND B 0.05705f
C5 VGND VPB 0.0093f
C6 Y S 0.06945f
C7 VPWR A 0.01276f
C8 VGND A 0.01655f
C9 Y VPWR 0.03415f
C10 VPB B 0.09901f
C11 VGND Y 0.02306f
C12 A B 0.02991f
C13 A VPB 0.03843f
C14 Y B 0.11304f
C15 Y VPB 0.01355f
C16 VPWR S 0.0319f
C17 VGND S 0.19007f
C18 VGND VPWR 0.02264f
C19 Y A 0
C20 VGND VNB 0.003f
C21 Y VNB 0f
C22 VPWR VNB 0f
C23 A VNB 0.05367f
C24 B VNB 0f
C25 S VNB 0.09098f
C26 VPB VNB 0.58873f
C27 a_286_199.t1 VNB 0.10465f
C28 a_286_199.n0 VNB 0.10751f
C29 a_286_199.n1 VNB 0.09836f
C30 a_286_199.t0 VNB 0.05959f
C31 a_286_199.t3 VNB 0.06106f
C32 a_286_199.t2 VNB 0.06886f
C33 a_286_199.n2 VNB 0.13786f
C34 a_286_199.n3 VNB 0.21316f
C35 a_33_297.t0 VNB 0.05133f
C36 a_33_297.n0 VNB 0.14695f
C37 a_33_297.t1 VNB 0.16587f
C38 a_33_297.t2 VNB 0.06033f
C39 a_561_297.t0 VNB 0.07372f
C40 a_561_297.t1 VNB 0.07575f
C41 a_751_297.t0 VNB 0.03954f
C42 a_751_297.t1 VNB 0.04577f
C43 a_115_47.t0 VNB 0.03734f
C44 a_115_47.t1 VNB 0.03881f
C45 VPB.t0 VNB 0.07422f
C46 VPB.t1 VNB 0.04683f
C47 VPB.t2 VNB 0.08851f
C48 VPB.t3 VNB 0.08429f
C49 VPB.t4 VNB 0.06041f
C50 VPB.t5 VNB 0.06416f
C51 S.n0 VNB 0.08305f
C52 S.n1 VNB 0.14111f
C53 S.n2 VNB 0.08361f
C54 B.n0 VNB 0.08875f
C55 B.n1 VNB 0.17795f
C56 B.n2 VNB 0.08931f
C57 B.n3 VNB 0.28032f
C58 A.n0 VNB 0.0718f
C59 VPWR.n0 VNB 0.41049f
C60 VPWR.t2 VNB 0.04931f
C61 VPWR.t0 VNB 0.05096f
C62 VPWR.n1 VNB 0.03965f
C63 VPWR.t1 VNB 0.0671f
C64 Y.t0 VNB 0.04758f
C65 Y.t1 VNB 0.04117f
C66 Y.n0 VNB 0.04989f
C67 Y.n1 VNB 0.05238f
C68 Y.n2 VNB 0.15842f
C69 Y.t2 VNB 0.09861f
C70 VGND.n0 VNB 0.00852f
C71 VGND.n1 VNB 0.02574f
C72 VGND.n2 VNB 0.00912f
C73 VGND.n3 VNB 0.02574f
C74 VGND.n4 VNB 0.00912f
C75 VGND.n5 VNB 0.02574f
C76 VGND.n6 VNB 0.00644f
C77 VGND.n7 VNB 0.06671f
C78 VGND.n8 VNB 0.13657f
C79 VGND.t1 VNB 0.028f
C80 VGND.t0 VNB 0.02351f
C81 VGND.n9 VNB 0.01176f
C82 VGND.t4 VNB 0.03094f
C83 VGND.t2 VNB 0.03639f
C84 VGND.n10 VNB 0.0306f
C85 VGND.n11 VNB 0.01546f
C86 VGND.t3 VNB 0.03956f
C87 VGND.n12 VNB 0.01871f
C88 VGND.n13 VNB 0.01693f
.ends
