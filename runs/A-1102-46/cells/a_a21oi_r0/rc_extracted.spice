* NGSPICE file created from a_a21oi_r0.ext - technology: sky130A

.subckt a_a21oi_r0 A B C VGND VNB VPB VPWR Y
X0 Y C a_27_297# VPB sky130_fd_pr__pfet_01v8_hvt ad=0.26 pd=2.52 as=0.135 ps=1.27 w=1 l=0.15 sa=1.16 sb=0.26
X1 a_27_297# A VPWR VPB sky130_fd_pr__pfet_01v8_hvt ad=0.135 pd=1.27 as=0.165 ps=1.33 w=1 l=0.15 sa=0.74 sb=0.68
X2 Y A a_109_47# VNB sky130_fd_pr__nfet_01v8 ad=0.08775 pd=0.92 as=0.10725 ps=0.98 w=0.65 l=0.15 sa=0.74 sb=0.68
X3 VGND C Y VNB sky130_fd_pr__nfet_01v8 ad=0.169 pd=1.82 as=0.08775 ps=0.92 w=0.65 l=0.15 sa=1.16 sb=0.26
X4 VPWR B a_27_297# VPB sky130_fd_pr__pfet_01v8_hvt ad=0.165 pd=1.33 as=0.26 ps=2.52 w=1 l=0.15 sa=0.26 sb=1.16
X5 a_109_47# B VGND VNB sky130_fd_pr__nfet_01v8 ad=0.10725 pd=0.98 as=0.169 ps=1.82 w=0.65 l=0.15 sa=0.26 sb=1.16
C0 Y a_27_297# 0.04092f
C1 VGND a_27_297# 0.01012f
C2 A VPB 0.0261f
C3 VPB B 0.0302f
C4 VGND Y 0.0516f
C5 VPWR a_27_297# 0.10851f
C6 VPB C 0.03719f
C7 a_109_47# a_27_297# 0.0018f
C8 Y VPWR 0.02718f
C9 VGND VPWR 0.02247f
C10 a_109_47# Y 0.0054f
C11 a_109_47# VGND 0.01205f
C12 A a_27_297# 0.02074f
C13 B a_27_297# 0.02478f
C14 A Y 0.02816f
C15 C a_27_297# 0.00699f
C16 A VGND 0.01738f
C17 a_109_47# VPWR 0.00149f
C18 Y B 0.00449f
C19 VGND B 0.02261f
C20 Y C 0.05733f
C21 VGND C 0.02467f
C22 VPB a_27_297# 0.01152f
C23 A VPWR 0.01526f
C24 VPWR B 0.01461f
C25 a_109_47# A 0.00114f
C26 Y VPB 0.01482f
C27 VPWR C 0.01344f
C28 VGND VPB 0.00769f
C29 A B 0.03636f
C30 VPWR VPB 0.04906f
C31 A C 0.02548f
C32 VGND VNB 0.28207f
C33 Y VNB 0.13189f
C34 VPWR VNB 0.28692f
C35 VPB VNB 0.42757f
C36 a_27_297# VNB 0.16652f
.ends
