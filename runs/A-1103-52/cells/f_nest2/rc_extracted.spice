* NGSPICE file created from f_nest2.ext - technology: sky130A

.subckt f_nest2 A B C D VGND VNB VPB VPWR Y
X0 a_149_297.t0 C.t1 a_349_297.t0 VPB.t0 sky130_fd_pr__pfet_01v8_hvt ad=0.26 pd=2.52 as=0.135 ps=1.27 w=1 l=0.15 sa=1.68 sb=0.26
X1 a_249_47.t1 B.t0 Y.t0 VNB.t2 sky130_fd_pr__nfet_01v8 ad=0.11375 pd=1 as=0.11375 ps=1 w=0.65 l=0.15 sa=0.76 sb=1.18
X2 a_349_297.t1 D.t1 VPWR.t1 VPB.t3 sky130_fd_pr__pfet_01v8_hvt ad=0.135 pd=1.27 as=0.175 ps=1.35 w=1 l=0.15 sa=1.26 sb=0.68
X3 Y.t1 A.t0 VGND.t0 VNB.t1 sky130_fd_pr__nfet_01v8 ad=0.11375 pd=1 as=0.169 ps=1.82 w=0.65 l=0.15 sa=0.26 sb=1.68
X4 VPWR.t0 B.t1 a_149_297.t2 VPB.t2 sky130_fd_pr__pfet_01v8_hvt ad=0.175 pd=1.35 as=0.175 ps=1.35 w=1 l=0.15 sa=0.76 sb=1.18
X5 a_249_47.t0 C.t0 VGND.t1 VNB.t0 sky130_fd_pr__nfet_01v8 ad=0.169 pd=1.82 as=0.08775 ps=0.92 w=0.65 l=0.15 sa=1.68 sb=0.26
X6 a_149_297.t1 A.t1 Y.t2 VPB.t1 sky130_fd_pr__pfet_01v8_hvt ad=0.175 pd=1.35 as=0.26 ps=2.52 w=1 l=0.15 sa=0.26 sb=1.68
X7 VGND.t2 D.t0 a_249_47.t2 VNB.t3 sky130_fd_pr__nfet_01v8 ad=0.08775 pd=0.92 as=0.11375 ps=1 w=0.65 l=0.15 sa=1.26 sb=0.68
R0 VGND VGND.n0 0.164506
R1 VGND.n0 VGND.n1 219.754
R2 VGND.n0 VGND.t0 303.058
R3 VGND.n1 VGND.t2 24.9236
R4 VGND.n1 VGND.t1 24.9236
R5 VPWR VPWR.n0 619.783
R6 VPWR.n0 VPWR.t0 34.4755
R7 VPWR.n0 VPWR.t1 34.4755
R8 Y.n0 Y.n1 185
R9 Y.n1 Y.n2 185
R10 Y Y.n0 6.4005
R11 Y.n5 Y.n0 12.8005
R12 Y.n5 Y.n2 12.8005
R13 Y Y.n5 20.4005
R14 Y.n3 Y.n4 290.423
R15 Y.n2 Y.n3 106.766
R16 Y.n3 Y 10.4328
R17 Y Y.n4 587.092
R18 Y.n4 Y.t2 26.5955
R19 Y.n1 Y.t1 32.3082
R20 Y.n1 Y.t0 32.3082
R21 C C.n0 158.4
R22 C.n0 C.t0 169.237
R23 C.n0 C.t1 241.536
R24 D D.n0 158.4
R25 D.n0 D.t0 169.237
R26 D.n0 D.t1 241.536
R27 B B.n0 158.4
R28 B.n0 B.t0 169.237
R29 B.n0 B.t1 241.536
R30 A A.n0 158.4
R31 A.n0 A.t0 169.237
R32 A.n0 A.t1 241.536
R33 VPB VPB.t1 310.748
R34 VPB.t1 VPB.t2 295.95
R35 VPB.t2 VPB.t3 295.95
R36 VPB.t3 VPB.t0 248.599
R37 VNB VNB.t1 1495.15
R38 VNB.t1 VNB.t2 1423.95
R39 VNB.t2 VNB.t3 1423.95
R40 VNB.t3 VNB.t0 1196.12
R41 a_249_47.t0 a_249_47.n0 289.529
R42 a_249_47.n0 a_249_47.t1 32.3082
R43 a_249_47.n0 a_249_47.t2 32.3082
R44 a_349_297.t0 a_349_297.t1 53.1905
R45 a_149_297.t0 a_149_297.n0 516.245
R46 a_149_297.n0 a_149_297.t1 34.4755
R47 a_149_297.n0 a_149_297.t2 34.4755
C0 A Y 0.0569f
C1 C Y 0
C2 VPWR Y 0.04674f
C3 VPB Y 0.02306f
C4 B Y 0.01309f
C5 D Y 0
C6 A VPWR 0.01466f
C7 A VPB 0.03386f
C8 VPWR C 0.01248f
C9 C VPB 0.03194f
C10 VGND Y 0.06623f
C11 B A 0.03085f
C12 VPWR VPB 0.08134f
C13 D C 0.03192f
C14 B VPWR 0.01627f
C15 B VPB 0.02917f
C16 VGND A 0.01745f
C17 D VPWR 0.01711f
C18 VGND C 0.01525f
C19 D VPB 0.02804f
C20 VGND VPWR 0.03005f
C21 VGND VPB 0.01012f
C22 D B 0.03085f
C23 VGND B 0.01742f
C24 D VGND 0.01669f
C25 VGND VNB 0.21908f
C26 VPWR VNB 0.46252f
C27 Y VNB 0f
C28 C VNB 0.05874f
C29 D VNB 0.02028f
C30 B VNB 0.02292f
C31 A VNB 0.04934f
C32 VPB VNB 0.44096f
C33 a_149_297.t0 VNB 0.15601f
C34 a_149_297.n0 VNB 0.11934f
C35 a_149_297.t1 VNB 0.04654f
C36 a_149_297.t2 VNB 0.04811f
C37 a_349_297.t0 VNB 0.03854f
C38 a_349_297.t1 VNB 0.04321f
C39 a_249_47.t0 VNB 0.09791f
C40 a_249_47.n0 VNB 0.08998f
C41 a_249_47.t1 VNB 0.03316f
C42 a_249_47.t2 VNB 0.03369f
C43 VPB.t0 VNB 0.09011f
C44 VPB.t1 VNB 0.04316f
C45 VPB.t2 VNB 0.04211f
C46 VPB.t3 VNB 0.03874f
C47 A.n0 VNB 0.05283f
C48 B.n0 VNB 0.05601f
C49 D.n0 VNB 0.0575f
C50 C.n0 VNB 0.04807f
C51 Y.n0 VNB 0.00437f
C52 Y.n1 VNB 0.02294f
C53 Y.t1 VNB 0.03037f
C54 Y.t0 VNB 0.03151f
C55 Y.n2 VNB 0.03253f
C56 Y.n3 VNB 0.06751f
C57 Y.n4 VNB 0.03887f
C58 Y.t2 VNB 0.03976f
C59 Y.n5 VNB 0.01817f
C60 VPWR.t0 VNB 0.04131f
C61 VPWR.t1 VNB 0.04205f
C62 VPWR.n0 VNB 0.0281f
C63 VGND.n0 VNB 0.14456f
C64 VGND.t2 VNB 0.02589f
C65 VGND.t1 VNB 0.02252f
C66 VGND.n1 VNB 0.0126f
C67 VGND.t0 VNB 0.03866f
.ends
