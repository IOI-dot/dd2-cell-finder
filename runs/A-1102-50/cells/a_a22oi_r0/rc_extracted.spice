* NGSPICE file created from a_a22oi_r0.ext - technology: sky130A

.subckt a_a22oi_r0 A B C D VGND VNB VPB VPWR Y
X0 a_59_297# A Y VPB sky130_fd_pr__pfet_01v8_hvt ad=0.175 pd=1.35 as=0.175 ps=1.35 w=1 l=0.15 sa=0.76 sb=1.26
X1 a_341_47# C Y VNB sky130_fd_pr__nfet_01v8 ad=0.11375 pd=1 as=0.11375 ps=1 w=0.65 l=0.15 sa=1.26 sb=0.76
X2 Y B a_59_297# VPB sky130_fd_pr__pfet_01v8_hvt ad=0.175 pd=1.35 as=0.26 ps=2.52 w=1 l=0.15 sa=0.26 sb=1.76
X3 Y A a_141_47# VNB sky130_fd_pr__nfet_01v8 ad=0.11375 pd=1 as=0.11375 ps=1 w=0.65 l=0.15 sa=0.76 sb=1.26
X4 a_59_297# D VPWR VPB sky130_fd_pr__pfet_01v8_hvt ad=0.26 pd=2.52 as=0.175 ps=1.35 w=1 l=0.15 sa=1.76 sb=0.26
X5 a_141_47# B VGND VNB sky130_fd_pr__nfet_01v8 ad=0.11375 pd=1 as=0.169 ps=1.82 w=0.65 l=0.15 sa=0.26 sb=1.76
X6 VPWR C a_59_297# VPB sky130_fd_pr__pfet_01v8_hvt ad=0.175 pd=1.35 as=0.175 ps=1.35 w=1 l=0.15 sa=1.26 sb=0.76
X7 VGND D a_341_47# VNB sky130_fd_pr__nfet_01v8 ad=0.169 pd=1.82 as=0.11375 ps=1 w=0.65 l=0.15 sa=1.76 sb=0.26
C0 Y a_59_297# 0.09825f
C1 VPB C 0.0282f
C2 a_141_47# A 0.00229f
C3 A B 0.03085f
C4 A VPB 0.0282f
C5 a_341_47# Y 0.01189f
C6 a_141_47# a_59_297# 0
C7 B a_59_297# 0.02595f
C8 VPB a_59_297# 0.02149f
C9 Y B 0.00571f
C10 a_141_47# Y 0.00647f
C11 Y VPB 0.01829f
C12 VPWR D 0.0145f
C13 VGND VPWR 0.02983f
C14 VGND D 0.01659f
C15 VPWR C 0.01538f
C16 a_141_47# B 0
C17 C D 0.03085f
C18 VGND C 0.01406f
C19 B VPB 0.03326f
C20 VPWR A 0.00959f
C21 VGND A 0.02104f
C22 A C 0.03085f
C23 VPWR a_59_297# 0.16808f
C24 a_59_297# D 0.01281f
C25 VGND a_59_297# 0.00848f
C26 VPWR Y 0.02043f
C27 a_59_297# C 0.01345f
C28 Y D 0.05639f
C29 VGND Y 0.08044f
C30 Y C 0.04787f
C31 A a_59_297# 0.01404f
C32 VPWR a_341_47# 0.00115f
C33 VGND a_341_47# 0.01081f
C34 Y A 0.0289f
C35 VPWR a_141_47# 0.00158f
C36 VPWR B 0.0094f
C37 VGND a_141_47# 0.0158f
C38 VGND B 0.03013f
C39 VPWR VPB 0.07865f
C40 VPB D 0.03234f
C41 VGND VPB 0.01213f
C42 VGND VNB 0.39233f
C43 VPWR VNB 0.32737f
C44 Y VNB 0.17365f
C45 VPB VNB 0.60476f
C46 a_341_47# VNB 0.02842f
C47 a_59_297# VNB 0.16355f
.ends
