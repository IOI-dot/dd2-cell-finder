* NGSPICE file created from f_xor3.ext - technology: sky130A

.subckt f_xor3 A B C VGND VNB VPB VPWR Y
X0 VGND a_581_199# a_535_47# VNB sky130_fd_pr__nfet_01v8 ad=0.25675 pd=1.44 as=0.11375 ps=1 w=0.65 l=0.15 sa=2.7 sb=3.86
X1 a_247_297# A a_147_297# VPB.t4 sky130_fd_pr__pfet_01v8_hvt ad=0.26 pd=2.52 as=0.175 ps=1.35 w=1 l=0.15 sa=0.76 sb=0.26
X2 a_353_297# A VPWR VPB.t5 sky130_fd_pr__pfet_01v8_hvt ad=0.175 pd=1.35 as=0.175 ps=1.35 w=1 l=0.15 sa=0.76 sb=0.76
X3 VGND A a_147_47# VNB sky130_fd_pr__nfet_01v8 ad=0.25675 pd=1.44 as=0.11375 ps=1 w=0.65 l=0.15 sa=0.76 sb=5.8
X4 VGND a_535_47# a_823_47# VNB sky130_fd_pr__nfet_01v8 ad=0.25675 pd=1.44 as=0.11375 ps=1 w=0.65 l=0.15 sa=4.14 sb=2.42
X5 a_535_47# A a_435_47# VNB sky130_fd_pr__nfet_01v8 ad=0.11375 pd=1 as=0.11375 ps=1 w=0.65 l=0.15 sa=2.2 sb=4.36
X6 Y.t1 a_1325_21# a_1029_297# VPB.t2 sky130_fd_pr__pfet_01v8_hvt ad=0.26 pd=2.52 as=0.175 ps=1.35 w=1 l=0.15 sa=1.48 sb=0.26
X7 a_147_47# B VGND VNB sky130_fd_pr__nfet_01v8 ad=0.11375 pd=1 as=0.169 ps=1.82 w=0.65 l=0.15 sa=0.26 sb=6.3
X8 a_147_297# B VPWR VPB.t8 sky130_fd_pr__pfet_01v8_hvt ad=0.175 pd=1.35 as=0.26 ps=2.52 w=1 l=0.15 sa=0.26 sb=0.76
X9 VPWR B a_353_297# VPB.t9 sky130_fd_pr__pfet_01v8_hvt ad=0.175 pd=1.35 as=0.26 ps=2.52 w=1 l=0.15 sa=0.26 sb=1.26
X10 a_823_47# C VGND VNB sky130_fd_pr__nfet_01v8 ad=0.11375 pd=1 as=0.25675 ps=1.44 w=0.65 l=0.15 sa=3.64 sb=2.92
X11 a_1111_47# C VGND VNB sky130_fd_pr__nfet_01v8 ad=0.18525 pd=1.22 as=0.25675 ps=1.44 w=0.65 l=0.15 sa=5.08 sb=1.48
X12 VGND a_1325_21# Y.t2 VNB sky130_fd_pr__nfet_01v8 ad=0.169 pd=1.82 as=0.11375 ps=1 w=0.65 l=0.15 sa=6.3 sb=0.26
X13 a_435_47# B VGND VNB sky130_fd_pr__nfet_01v8 ad=0.11375 pd=1 as=0.25675 ps=1.44 w=0.65 l=0.15 sa=1.7 sb=4.86
X14 a_923_297# a_535_47# a_823_297# VPB.t0 sky130_fd_pr__pfet_01v8_hvt ad=0.26 pd=2.52 as=0.175 ps=1.35 w=1 l=0.15 sa=0.76 sb=0.26
X15 a_1029_297# a_535_47# VPWR VPB.t1 sky130_fd_pr__pfet_01v8_hvt ad=0.175 pd=1.35 as=0.285 ps=1.57 w=1 l=0.15 sa=0.98 sb=0.76
X16 Y.t0 a_535_47# a_1111_47# VNB sky130_fd_pr__nfet_01v8 ad=0.11375 pd=1 as=0.18525 ps=1.22 w=0.65 l=0.15 sa=5.8 sb=0.76
X17 a_535_47# a_581_199# a_353_297# VPB.t3 sky130_fd_pr__pfet_01v8_hvt ad=0.26 pd=2.52 as=0.175 ps=1.35 w=1 l=0.15 sa=1.26 sb=0.26
X18 a_823_297# C VPWR VPB.t6 sky130_fd_pr__pfet_01v8_hvt ad=0.175 pd=1.35 as=0.26 ps=2.52 w=1 l=0.15 sa=0.26 sb=0.76
X19 VPWR C a_1029_297# VPB.t7 sky130_fd_pr__pfet_01v8_hvt ad=0.285 pd=1.57 as=0.26 ps=2.52 w=1 l=0.15 sa=0.26 sb=1.48
R0 Y.n2 Y.n1 585
R1 Y.n3 Y.n2 585
R2 Y.n6 Y.n5 185
R3 Y.n5 Y.n4 185
R4 Y.n4 Y.n3 121.882
R5 Y.n5 Y.t0 32.3082
R6 Y.n5 Y.t2 32.3082
R7 Y.n2 Y.t1 26.5955
R8 Y.n0 Y 20.4005
R9 Y.n6 Y.n0 12.8005
R10 Y.n4 Y.n0 12.8005
R11 Y.n3 Y 7.41868
R12 Y.n1 Y 6.92243
R13 Y Y.n6 6.4005
R14 Y.n1 Y 2.47323
R15 VPB.t4 VPB.t9 556.386
R16 VPB.t3 VPB.t6 556.386
R17 VPB.t0 VPB.t7 556.386
R18 VPB.t7 VPB.t1 426.168
R19 VPB VPB.t8 304.829
R20 VPB.t8 VPB.t4 295.95
R21 VPB.t9 VPB.t5 295.95
R22 VPB.t5 VPB.t3 295.95
R23 VPB.t6 VPB.t0 295.95
R24 VPB.t1 VPB.t2 295.95
C0 VPWR a_1029_297# 0.11919f
C1 VPB a_247_297# 0.00501f
C2 VGND a_247_297# 0.00159f
C3 a_147_47# VPB 0
C4 a_147_47# VGND 0.03964f
C5 VPWR VPB 0.21934f
C6 VPWR VGND 0.08727f
C7 B a_581_199# 0
C8 Y a_1029_297# 0.02855f
C9 A VPB 0.06305f
C10 A VGND 0.09328f
C11 Y VPB 0.02318f
C12 Y VGND 0.07152f
C13 a_1029_297# a_1325_21# 0.00594f
C14 C a_581_199# 0.00943f
C15 C a_1111_47# 0.00264f
C16 a_1325_21# VPB 0.03501f
C17 VGND a_1325_21# 0.01749f
C18 a_535_47# a_1029_297# 0.06742f
C19 a_535_47# VPB 0.10968f
C20 a_535_47# VGND 0.11908f
C21 a_353_297# a_581_199# 0.01365f
C22 VPWR a_581_199# 0.01741f
C23 C a_823_47# 0.01769f
C24 VPWR a_1111_47# 0.00257f
C25 VGND a_147_297# 0.0024f
C26 C a_923_297# 0
C27 A a_581_199# 0.03207f
C28 Y a_581_199# 0
C29 a_353_297# B 0.03368f
C30 Y a_1111_47# 0.00823f
C31 C a_823_297# 0.00137f
C32 B a_247_297# 0.01528f
C33 a_147_47# B 0.00558f
C34 VPWR B 0.05626f
C35 a_823_297# a_923_297# 0.00166f
C36 A B 0.14401f
C37 a_535_47# a_581_199# 0.04877f
C38 VPWR a_435_47# 0.00115f
C39 a_535_47# a_1111_47# 0.00635f
C40 VPWR C 0.0342f
C41 VPWR a_823_47# 0.00101f
C42 A a_435_47# 0.00789f
C43 VPWR a_923_297# 0.026f
C44 Y C 0.00549f
C45 Y a_823_47# 0
C46 a_535_47# B 0.00513f
C47 VPWR a_823_297# 0.01145f
C48 Y a_923_297# 0
C49 a_1029_297# VPB 0.00936f
C50 VGND a_1029_297# 0.00464f
C51 C a_1325_21# 0
C52 a_353_297# a_247_297# 0.02084f
C53 VGND VPB 0.02109f
C54 a_535_47# a_435_47# 0.00389f
C55 a_353_297# VPWR 0.11193f
C56 a_535_47# C 0.16689f
C57 a_535_47# a_823_47# 0.00253f
C58 VPWR a_247_297# 0.03567f
C59 VPWR a_147_47# 0.00143f
C60 a_353_297# A 0.0269f
C61 a_535_47# a_923_297# 0.01782f
C62 A a_247_297# 0.00607f
C63 a_147_297# B 0.00966f
C64 A a_147_47# 0.00764f
C65 VPWR A 0.03552f
C66 a_535_47# a_823_297# 0.01759f
C67 Y VPWR 0.03907f
C68 VPWR a_1325_21# 0.01663f
C69 a_353_297# a_535_47# 0.03515f
C70 a_535_47# a_147_47# 0
C71 a_535_47# VPWR 0.12345f
C72 Y a_1325_21# 0.05181f
C73 a_535_47# A 0.01488f
C74 VPB a_581_199# 0.03447f
C75 Y a_535_47# 0.02085f
C76 VGND a_581_199# 0.01598f
C77 VGND a_1111_47# 0.0193f
C78 a_353_297# a_147_297# 0
C79 a_535_47# a_1325_21# 0.03315f
C80 a_147_297# a_247_297# 0.00499f
C81 VPWR a_147_297# 0.01835f
C82 B VPB 0.08551f
C83 VGND B 0.04884f
C84 C a_1029_297# 0.01412f
C85 a_435_47# VGND 0.01061f
C86 C VPB 0.07019f
C87 C VGND 0.09118f
C88 a_1029_297# a_923_297# 0.00943f
C89 a_823_47# VGND 0.03387f
C90 VPB a_923_297# 0.00448f
C91 VGND a_923_297# 0.00171f
C92 a_1029_297# a_823_297# 0.00151f
C93 VGND a_823_297# 0.00177f
C94 a_353_297# VPB 0.01033f
C95 a_353_297# VGND 0.00421f
C96 VGND VNB 1.15557f
C97 Y VNB 0.10616f
C98 VPWR VNB 0.67337f
C99 VPB VNB 1.54361f
C100 a_823_47# VNB 0.17741f
C101 a_147_47# VNB 0.08961f
C102 a_1029_297# VNB 0.04247f
C103 a_923_297# VNB 0
C104 a_353_297# VNB 0.00519f
C105 a_247_297# VNB 0.07361f
C106 a_147_297# VNB 0.07361f
C107 VPB.t2 VNB 0.0982f
C108 VPB.t1 VNB 0.05445f
C109 VPB.t7 VNB 0.07409f
C110 VPB.t0 VNB 0.06427f
C111 VPB.t6 VNB 0.06427f
C112 VPB.t3 VNB 0.06427f
C113 VPB.t5 VNB 0.04463f
C114 VPB.t9 VNB 0.06427f
C115 VPB.t4 VNB 0.06427f
C116 VPB.t8 VNB 0.0453f
C117 Y.n0 VNB 0.01894f
C118 Y.t2 VNB 0.01196f
C119 Y.t0 VNB 0.01196f
C120 Y.n1 VNB 0.01156f
C121 Y.t1 VNB 0.05564f
C122 Y.n2 VNB 0.04047f
C123 Y.n3 VNB 0.05488f
C124 Y.n4 VNB 0.03686f
C125 Y.n5 VNB 0.02391f
C126 Y.n6 VNB 0.00456f
.ends
