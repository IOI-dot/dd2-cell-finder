* NGSPICE file created from f_maj4.ext - technology: sky130A

.subckt f_maj4 A B C D VGND VNB VPB VPWR Y
X0 a_133_297# B a_51_297# VPB sky130_fd_pr__pfet_01v8_hvt ad=0.165 pd=1.33 as=0.26 ps=2.52 w=1 l=0.15
X1 a_51_297# C a_229_47# VNB sky130_fd_pr__nfet_01v8 ad=0.10725 pd=0.98 as=0.13325 ps=1.06 w=0.65 l=0.15
X2 a_133_47# B VGND VNB sky130_fd_pr__nfet_01v8 ad=0.10725 pd=0.98 as=0.169 ps=1.82 w=0.65 l=0.15
X3 a_533_47# C a_229_47# VNB sky130_fd_pr__nfet_01v8 ad=0.10725 pd=0.98 as=0.10725 ps=0.98 w=0.65 l=0.15
X4 a_229_47# D a_51_297# VNB sky130_fd_pr__nfet_01v8 ad=0.10725 pd=0.98 as=0.10725 ps=0.98 w=0.65 l=0.15
X5 Y a_51_297# VPWR VPB sky130_fd_pr__pfet_01v8_hvt ad=0.26 pd=2.52 as=0.165 ps=1.33 w=1 l=0.15
X6 VPWR D a_133_297# VPB sky130_fd_pr__pfet_01v8_hvt ad=0.165 pd=1.33 as=0.165 ps=1.33 w=1 l=0.15
X7 Y a_51_297# VGND VNB sky130_fd_pr__nfet_01v8 ad=0.169 pd=1.82 as=0.10725 ps=0.98 w=0.65 l=0.15
X8 a_51_297# A a_133_297# VPB sky130_fd_pr__pfet_01v8_hvt ad=0.205 pd=1.41 as=0.165 ps=1.33 w=1 l=0.15
X9 VGND D a_533_47# VNB sky130_fd_pr__nfet_01v8 ad=0.10725 pd=0.98 as=0.10725 ps=0.98 w=0.65 l=0.15
X10 a_341_297# C a_51_297# VPB sky130_fd_pr__pfet_01v8_hvt ad=0.165 pd=1.33 as=0.205 ps=1.41 w=1 l=0.15
X11 a_133_297# C VPWR VPB sky130_fd_pr__pfet_01v8_hvt ad=0.165 pd=1.33 as=0.165 ps=1.33 w=1 l=0.15
X12 a_229_47# A a_133_47# VNB sky130_fd_pr__nfet_01v8 ad=0.13325 pd=1.06 as=0.10725 ps=0.98 w=0.65 l=0.15
X13 VPWR D a_341_297# VPB sky130_fd_pr__pfet_01v8_hvt ad=0.165 pd=1.33 as=0.165 ps=1.33 w=1 l=0.15
.ends
