* NGSPICE file created from f_maj3.ext - technology: sky130A

.subckt f_maj3 A B C VGND VNB VPB VPWR Y
X0 Y a_145_47# VGND VNB sky130_fd_pr__nfet_01v8 ad=0.169 pd=1.82 as=0.16087 ps=1.145 w=0.65 l=0.15
X1 VGND B a_274_47# VNB sky130_fd_pr__nfet_01v8 ad=0.16087 pd=1.145 as=0.08775 ps=0.92 w=0.65 l=0.15
X2 a_145_297# C VPWR VPB sky130_fd_pr__pfet_01v8_hvt ad=0.2475 pd=1.495 as=0.26 ps=2.52 w=1 l=0.15
X3 VPWR B a_487_297# VPB sky130_fd_pr__pfet_01v8_hvt ad=0.2475 pd=1.495 as=0.4 ps=1.8 w=1 l=0.15
X4 a_63_47# A VGND VNB sky130_fd_pr__nfet_01v8 ad=0.26 pd=1.45 as=0.16087 ps=1.145 w=0.65 l=0.15
X5 a_145_47# C a_63_47# VNB sky130_fd_pr__nfet_01v8 ad=0.16087 pd=1.145 as=0.169 ps=1.82 w=0.65 l=0.15
X6 a_487_297# A a_145_297# VPB sky130_fd_pr__pfet_01v8_hvt ad=0.4 pd=1.8 as=0.2475 ps=1.495 w=1 l=0.15
X7 VGND B a_63_47# VNB sky130_fd_pr__nfet_01v8 ad=0.16087 pd=1.145 as=0.26 ps=1.45 w=0.65 l=0.15
X8 a_145_297# B a_145_47# VPB sky130_fd_pr__pfet_01v8_hvt ad=0.2475 pd=1.495 as=0.135 ps=1.27 w=1 l=0.15
X9 a_274_47# A a_145_47# VNB sky130_fd_pr__nfet_01v8 ad=0.08775 pd=0.92 as=0.16087 ps=1.145 w=0.65 l=0.15
X10 a_145_47# A a_145_297# VPB sky130_fd_pr__pfet_01v8_hvt ad=0.135 pd=1.27 as=0.2475 ps=1.495 w=1 l=0.15
X11 Y a_145_47# VPWR VPB sky130_fd_pr__pfet_01v8_hvt ad=0.26 pd=2.52 as=0.2475 ps=1.495 w=1 l=0.15
.ends
