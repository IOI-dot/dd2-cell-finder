* NGSPICE file created from a_a21o_r2.ext - technology: sky130A

.subckt a_a21o_r2 A B C VGND VNB VPB VPWR Y
X0 VGND.t0 B.t0 a_243_47.t0 VNB.t0 sky130_fd_pr__nfet_01v8 ad=0.25675 pd=1.44 as=0.11375 ps=1 w=0.65 l=0.15 sa=1.26 sb=1.2
X1 a_143_297.t0 B.t1 VPWR.t0 VPB.t1 sky130_fd_pr__pfet_01v8_hvt ad=0.26 pd=2.52 as=0.175 ps=1.35 w=1 l=0.15 sa=1.26 sb=0.26
X2 a_243_47.t1 A.t0 a_61_297.t0 VNB.t2 sky130_fd_pr__nfet_01v8 ad=0.11375 pd=1 as=0.11375 ps=1 w=0.65 l=0.15 sa=0.76 sb=1.7
X3 VPWR.t2 A.t1 a_143_297.t1 VPB.t2 sky130_fd_pr__pfet_01v8_hvt ad=0.175 pd=1.35 as=0.175 ps=1.35 w=1 l=0.15 sa=0.76 sb=0.76
X4 Y.t0 a_61_297.t4 VPWR.t1 VPB.t0 sky130_fd_pr__pfet_01v8_hvt ad=0.26 pd=2.52 as=0.26 ps=2.52 w=1 l=0.15 sa=0.26 sb=0.26
X5 Y.t1 a_61_297.t3 VGND.t2 VNB.t1 sky130_fd_pr__nfet_01v8 ad=0.169 pd=1.82 as=0.25675 ps=1.44 w=0.65 l=0.15 sa=2.2 sb=0.26
X6 a_61_297.t1 C.t0 VGND.t1 VNB.t3 sky130_fd_pr__nfet_01v8 ad=0.11375 pd=1 as=0.169 ps=1.82 w=0.65 l=0.15 sa=0.26 sb=2.2
X7 a_143_297.t2 C.t1 a_61_297.t2 VPB.t3 sky130_fd_pr__pfet_01v8_hvt ad=0.175 pd=1.35 as=0.26 ps=2.52 w=1 l=0.15 sa=0.26 sb=1.26
R0 VGND VGND.n0 0.11166
R1 VGND.n0 VGND.n1 215.941
R2 VGND.n0 VGND.t1 173.012
R3 VGND.n1 VGND.t0 72.9236
R4 VGND.n1 VGND.t2 72.9236
R5 Y Y.n0 6.4005
R6 Y.n1 Y.n2 289.807
R7 Y.n1 Y.n0 102.981
R8 Y Y.n1 13.5509
R9 Y Y.n2 587.721
R10 Y.n2 Y.t0 26.5955
R11 Y.n0 Y.t1 268.077
R12 VPWR VPWR.n0 0.653884
R13 VPWR.n0 VPWR.t1 269.283
R14 VPWR.n0 VPWR.n1 619.292
R15 VPWR.n1 VPWR.t2 34.4755
R16 VPWR.n1 VPWR.t0 34.4755
R17 B B.n0 158.4
R18 B.n0 B.t0 169.237
R19 B.n0 B.t1 241.536
R20 A A.n0 158.4
R21 A.n0 A.t0 169.237
R22 A.n0 A.t1 241.536
R23 C C.n0 158.4
R24 C.n0 C.t0 169.237
R25 C.n0 C.t1 241.536
R26 VPB VPB.t3 292.991
R27 VPB.t3 VPB.t2 295.95
R28 VPB.t2 VPB.t1 295.95
R29 VPB.t1 VPB.t0 556.386
R30 VNB VNB.t3 1409.71
R31 VNB.t3 VNB.t2 1423.95
R32 VNB.t2 VNB.t0 1423.95
R33 VNB.t0 VNB.t1 2677.02
R34 a_243_47.t0 a_243_47.t1 64.6159
R35 a_143_297.t0 a_143_297.n0 998.452
R36 a_143_297.n0 a_143_297.t2 34.4755
R37 a_143_297.n0 a_143_297.t1 34.4755
R38 a_61_297.t2 a_61_297.n2 393.003
R39 a_61_297.n2 a_61_297.n1 202.732
R40 a_61_297.n1 a_61_297.t3 169.237
R41 a_61_297.n1 a_61_297.t4 241.536
R42 a_61_297.n2 a_61_297.n0 175.663
R43 a_61_297.n0 a_61_297.t1 32.3082
R44 a_61_297.n0 a_61_297.t0 32.3082
C0 A C 0.03085f
C1 B VPB 0.03257f
C2 VGND A 0.01373f
C3 VGND Y 0.04241f
C4 A Y 0
C5 VPWR VPB 0.10935f
C6 VPWR B 0.01619f
C7 C VPB 0.03235f
C8 VGND VPB 0.01366f
C9 A VPB 0.0282f
C10 VGND B 0.01551f
C11 A B 0.03085f
C12 Y VPB 0.01779f
C13 Y B 0
C14 C VPWR 0.01269f
C15 VGND VPWR 0.03727f
C16 A VPWR 0.01567f
C17 Y VPWR 0.07517f
C18 VGND C 0.02979f
C19 VGND VNB 0.18282f
C20 Y VNB 0f
C21 VPWR VNB 0.14527f
C22 B VNB 0.02981f
C23 A VNB 0.01963f
C24 C VNB 0.06112f
C25 VPB VNB 0.48371f
C26 a_61_297.t2 VNB 0.14884f
C27 a_61_297.n0 VNB 0.06526f
C28 a_61_297.t1 VNB 0.0332f
C29 a_61_297.t0 VNB 0.03707f
C30 a_61_297.n1 VNB 0.05126f
C31 a_61_297.n2 VNB 0.2376f
C32 a_143_297.t0 VNB 0.15408f
C33 a_143_297.t2 VNB 0.04493f
C34 a_143_297.t1 VNB 0.05029f
C35 a_143_297.n0 VNB 0.07878f
C36 a_243_47.t0 VNB 0.03213f
C37 a_243_47.t1 VNB 0.03289f
C38 VPB.t0 VNB 0.11193f
C39 VPB.t1 VNB 0.06199f
C40 VPB.t2 VNB 0.04305f
C41 VPB.t3 VNB 0.04283f
C42 C.n0 VNB 0.04792f
C43 A.n0 VNB 0.05875f
C44 B.n0 VNB 0.05664f
C45 VPWR.n0 VNB 0.18455f
C46 VPWR.t2 VNB 0.043f
C47 VPWR.t0 VNB 0.04195f
C48 VPWR.n1 VNB 0.02864f
C49 VPWR.t1 VNB 0.06555f
C50 Y.t1 VNB 0.04247f
C51 Y.n0 VNB 0.02873f
C52 Y.n1 VNB 0.04804f
C53 Y.n2 VNB 0.03453f
C54 Y.t0 VNB 0.03365f
C55 VGND.n0 VNB 0.18087f
C56 VGND.t0 VNB 0.03335f
C57 VGND.t2 VNB 0.02867f
C58 VGND.n1 VNB 0.02768f
C59 VGND.t1 VNB 0.03499f
.ends
