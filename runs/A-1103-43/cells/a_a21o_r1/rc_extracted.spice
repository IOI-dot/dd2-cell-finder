* NGSPICE file created from a_a21o_r1.ext - technology: sky130A

.subckt a_a21o_r1 A B C VGND VNB VPB VPWR Y
X0 VPWR.t1 a_97_199.t4 Y.t0 VPB.t0 sky130_fd_pr__pfet_01v8_hvt ad=0.26 pd=2.52 as=0.26 ps=2.52 w=1 l=0.15 sa=0.26 sb=0.26
X1 a_257_297.t1 A.t1 VPWR.t2 VPB.t2 sky130_fd_pr__pfet_01v8_hvt ad=0.135 pd=1.27 as=0.175 ps=1.35 w=1 l=0.15 sa=0.76 sb=0.68
X2 VGND.t0 C.t0 a_97_199.t1 VNB.t0 sky130_fd_pr__nfet_01v8 ad=0.169 pd=1.82 as=0.08775 ps=0.92 w=0.65 l=0.15 sa=2.12 sb=0.26
X3 a_97_199.t2 A.t0 a_339_47.t0 VNB.t1 sky130_fd_pr__nfet_01v8 ad=0.08775 pd=0.92 as=0.11375 ps=1 w=0.65 l=0.15 sa=1.7 sb=0.68
X4 VPWR.t0 B.t1 a_257_297.t2 VPB.t3 sky130_fd_pr__pfet_01v8_hvt ad=0.175 pd=1.35 as=0.26 ps=2.52 w=1 l=0.15 sa=0.26 sb=1.18
X5 a_339_47.t1 B.t0 VGND.t1 VNB.t3 sky130_fd_pr__nfet_01v8 ad=0.11375 pd=1 as=0.25675 ps=1.44 w=0.65 l=0.15 sa=1.2 sb=1.18
X6 a_97_199.t0 C.t1 a_257_297.t0 VPB.t1 sky130_fd_pr__pfet_01v8_hvt ad=0.26 pd=2.52 as=0.135 ps=1.27 w=1 l=0.15 sa=1.18 sb=0.26
X7 VGND.t2 a_97_199.t3 Y.t1 VNB.t2 sky130_fd_pr__nfet_01v8 ad=0.25675 pd=1.44 as=0.169 ps=1.82 w=0.65 l=0.15 sa=0.26 sb=2.12
R0 VGND VGND.n1 0.287696
R1 VGND.n1 VGND.t0 303.466
R2 VGND.n1 VGND.n0 213.611
R3 VGND.n0 VGND.t2 72.9236
R4 VGND.n0 VGND.t1 72.9236
R5 VPWR VPWR.n0 0.531494
R6 VPWR.n0 VPWR.n1 619.447
R7 VPWR.n1 VPWR.t0 34.4755
R8 VPWR.n1 VPWR.t2 34.4755
R9 VPWR.n0 VPWR.t1 269.474
R10 Y.n0 Y.n1 290.423
R11 Y Y.n0 103.754
R12 Y Y.n0 10.4328
R13 Y Y.n1 587.092
R14 Y.n1 Y.t0 26.5955
R15 Y Y.t1 274.478
R16 C C.n0 158.4
R17 C.n0 C.t0 169.237
R18 C.n0 C.t1 241.536
R19 A A.n0 158.4
R20 A.n0 A.t0 169.237
R21 A.n0 A.t1 241.536
R22 B B.n0 158.4
R23 B.n0 B.t0 169.237
R24 B.n0 B.t1 241.536
R25 VPB VPB.t0 316.668
R26 VPB.t0 VPB.t3 556.386
R27 VPB.t3 VPB.t2 295.95
R28 VPB.t2 VPB.t1 248.599
R29 VNB VNB.t2 1523.62
R30 VNB.t2 VNB.t3 2677.02
R31 VNB.t3 VNB.t1 1423.95
R32 VNB.t1 VNB.t0 1196.12
R33 a_339_47.t0 a_339_47.t1 64.6159
R34 a_257_297.n0 a_257_297.t2 468.918
R35 a_257_297.n0 a_257_297.t1 26.5955
R36 a_257_297.t0 a_257_297.n0 26.5955
R37 a_97_199.t0 a_97_199.n1 434.396
R38 a_97_199.n1 a_97_199.n2 98.788
R39 a_97_199.n2 a_97_199.t2 24.9236
R40 a_97_199.n2 a_97_199.t1 24.9236
R41 a_97_199.n1 a_97_199.n0 279.909
R42 a_97_199.n0 a_97_199.t3 169.237
R43 a_97_199.n0 a_97_199.t4 241.536
C0 Y A 0
C1 B A 0.03085f
C2 Y VPWR 0.08504f
C3 B VPWR 0.01628f
C4 A VPB 0.02804f
C5 VPWR VPB 0.10265f
C6 C VGND 0.01599f
C7 Y VGND 0.04982f
C8 B VGND 0.01575f
C9 Y C 0
C10 VPWR A 0.01582f
C11 VGND VPB 0.00999f
C12 C VPB 0.03395f
C13 Y B 0
C14 Y VPB 0.02334f
C15 B VPB 0.03314f
C16 VGND A 0.01296f
C17 VGND VPWR 0.03647f
C18 C A 0.03192f
C19 C VPWR 0.01504f
C20 VGND VNB 0.17473f
C21 VPWR VNB 0.18368f
C22 Y VNB 0.00205f
C23 C VNB 0.05003f
C24 A VNB 0.02077f
C25 B VNB 0.03334f
C26 VPB VNB 0.48642f
C27 a_97_199.t0 VNB 0.11782f
C28 a_97_199.n0 VNB 0.0658f
C29 a_97_199.n1 VNB 0.23114f
C30 a_97_199.n2 VNB 0.02614f
C31 a_97_199.t2 VNB 0.032f
C32 a_97_199.t1 VNB 0.03016f
C33 a_257_297.t0 VNB 0.04055f
C34 a_257_297.n0 VNB 0.11022f
C35 a_257_297.t2 VNB 0.15117f
C36 a_257_297.t1 VNB 0.0431f
C37 a_339_47.t0 VNB 0.03221f
C38 a_339_47.t1 VNB 0.03095f
C39 VPB.t0 VNB 0.06372f
C40 VPB.t1 VNB 0.09332f
C41 VPB.t2 VNB 0.03975f
C42 VPB.t3 VNB 0.06221f
C43 B.n0 VNB 0.05322f
C44 A.n0 VNB 0.05675f
C45 C.n0 VNB 0.0516f
C46 Y.t1 VNB 0.04267f
C47 Y.n0 VNB 0.06007f
C48 Y.n1 VNB 0.03559f
C49 Y.t0 VNB 0.03284f
C50 VPWR.n0 VNB 0.17088f
C51 VPWR.t1 VNB 0.06535f
C52 VPWR.t0 VNB 0.04061f
C53 VPWR.t2 VNB 0.04235f
C54 VPWR.n1 VNB 0.02943f
C55 VGND.t2 VNB 0.02797f
C56 VGND.t1 VNB 0.03228f
C57 VGND.n0 VNB 0.02763f
C58 VGND.n1 VNB 0.17542f
C59 VGND.t0 VNB 0.03539f
.ends
