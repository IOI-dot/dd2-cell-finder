* NGSPICE file created from f_mux2.ext - technology: sky130A

.subckt f_mux2 A B C VGND VNB VPB VPWR Y
X0 VPWR B a_243_297# VPB sky130_fd_pr__pfet_01v8_hvt ad=0.175 pd=1.35 as=0.175 ps=1.35 w=1 l=0.15 sa=1.26 sb=0.76
X1 Y a_325_297# VPWR VPB sky130_fd_pr__pfet_01v8_hvt ad=0.26 pd=2.52 as=0.26 ps=2.52 w=1 l=0.15 sa=0.26 sb=0.26
X2 a_525_47# B a_325_297# VNB sky130_fd_pr__nfet_01v8 ad=0.11375 pd=1 as=0.11375 ps=1 w=0.65 l=0.15 sa=2.2 sb=1.7
X3 VGND C a_55_47# VNB sky130_fd_pr__nfet_01v8 ad=0.25675 pd=1.44 as=0.169 ps=1.82 w=0.65 l=0.15 sa=0.26 sb=3.64
X4 Y a_325_297# VGND VNB sky130_fd_pr__nfet_01v8 ad=0.169 pd=1.82 as=0.25675 ps=1.44 w=0.65 l=0.15 sa=3.64 sb=0.26
X5 a_325_297# a_55_47# a_325_47# VNB sky130_fd_pr__nfet_01v8 ad=0.11375 pd=1 as=0.11375 ps=1 w=0.65 l=0.15 sa=1.7 sb=2.2
X6 a_243_297# a_55_47# a_325_297# VPB sky130_fd_pr__pfet_01v8_hvt ad=0.175 pd=1.35 as=0.175 ps=1.35 w=1 l=0.15 sa=0.76 sb=1.26
X7 a_325_47# A VGND VNB sky130_fd_pr__nfet_01v8 ad=0.11375 pd=1 as=0.25675 ps=1.44 w=0.65 l=0.15 sa=1.2 sb=2.7
X8 VPWR C a_55_47# VPB sky130_fd_pr__pfet_01v8_hvt ad=0.26 pd=2.52 as=0.26 ps=2.52 w=1 l=0.15 sa=0.26 sb=0.26
X9 a_325_297# A a_243_297# VPB sky130_fd_pr__pfet_01v8_hvt ad=0.175 pd=1.35 as=0.26 ps=2.52 w=1 l=0.15 sa=0.26 sb=1.76
X10 a_243_297# C VPWR VPB sky130_fd_pr__pfet_01v8_hvt ad=0.26 pd=2.52 as=0.175 ps=1.35 w=1 l=0.15 sa=1.76 sb=0.26
X11 VGND C a_525_47# VNB sky130_fd_pr__nfet_01v8 ad=0.25675 pd=1.44 as=0.11375 ps=1 w=0.65 l=0.15 sa=2.7 sb=1.2
C0 C a_55_47# 0.20796f
C1 a_243_297# VPWR 0.19803f
C2 A a_55_47# 0.06052f
C3 a_325_297# VPWR 0.06173f
C4 C VPB 0.07151f
C5 B VGND 0.01018f
C6 A VPB 0.03412f
C7 a_55_47# VGND 0.07277f
C8 a_325_47# a_55_47# 0.004f
C9 VPB VGND 0.01366f
C10 VPWR Y 0.07048f
C11 B a_55_47# 0.03434f
C12 C a_243_297# 0.01921f
C13 A a_243_297# 0.02107f
C14 C a_325_297# 0.12548f
C15 B VPB 0.0282f
C16 A a_325_297# 0.00605f
C17 VPB a_55_47# 0.05824f
C18 a_325_297# a_525_47# 0.01192f
C19 a_243_297# VGND 0.00416f
C20 a_325_297# VGND 0.10453f
C21 a_325_47# a_243_297# 0
C22 a_325_47# a_325_297# 0.00647f
C23 C Y 0.00193f
C24 a_525_47# Y 0
C25 C VPWR 0.05215f
C26 A VPWR 0.00903f
C27 VGND Y 0.04285f
C28 B a_243_297# 0.01343f
C29 B a_325_297# 0.04665f
C30 a_243_297# a_55_47# 0.02831f
C31 a_325_297# a_55_47# 0.0488f
C32 VPWR VGND 0.02555f
C33 VPB a_243_297# 0.01534f
C34 VPB a_325_297# 0.06158f
C35 B Y 0
C36 B VPWR 0.01535f
C37 VPB Y 0.01719f
C38 a_55_47# VPWR 0.09037f
C39 A C 0.01745f
C40 C a_525_47# 0.0032f
C41 VPB VPWR 0.14622f
C42 a_243_297# a_325_297# 0.08931f
C43 C VGND 0.12703f
C44 A VGND 0.02002f
C45 C a_325_47# 0.0052f
C46 a_525_47# VGND 0.00965f
C47 A a_325_47# 0
C48 a_325_47# VGND 0.01079f
C49 a_325_297# Y 0.04425f
C50 C B 0.04552f
C51 VGND VNB 0.67618f
C52 Y VNB 0.14757f
C53 VPWR VNB 0.51764f
C54 VPB VNB 0.95915f
C55 a_325_47# VNB 0.15926f
C56 a_243_297# VNB 0.02987f
C57 a_325_297# VNB 0.12605f
.ends
