* NGSPICE file created from a_xor3_r3.ext - technology: sky130A

.subckt a_xor3_r3 A B C Y VGND VPWR VPB VNB A_uq0
X0 a_153_297.t2 C.t3 VPWR.t5 VPB.t8 sky130_fd_pr__pfet_01v8_hvt ad=0.26 pd=2.52 as=0.135 ps=1.27 w=1 l=0.15
X1 a_927_47.t1 B.t1 VGND.t2 VNB.t4 sky130_fd_pr__nfet_01v8 ad=0.20638 pd=1.285 as=0.25675 ps=1.44 w=0.65 l=0.15
X2 VPWR.t3 a_256_199.t6 a_153_297.t0 VPB.t1 sky130_fd_pr__pfet_01v8_hvt ad=0.135 pd=1.27 as=0.3175 ps=1.635 w=1 l=0.15
X3 VGND.t4 a_1138_21.t3 a_256_199.t0 VNB.t2 sky130_fd_pr__nfet_01v8 ad=0.25675 pd=1.44 as=0.08775 ps=0.92 w=0.65 l=0.15
X4 a_256_199.t1 a_1138_21.t4 a_845_297.t0 VPB.t2 sky130_fd_pr__pfet_01v8_hvt ad=0.26 pd=2.52 as=0.135 ps=1.27 w=1 l=0.15
X5 a_123_21.t1 a_256_199.t5 a_582_297.t0 VPB.t0 sky130_fd_pr__pfet_01v8_hvt ad=0.26 pd=2.52 as=0.3175 ps=1.635 w=1 l=0.15
X6 VGND.t0 A_uq0.t0 a_1138_21.t2 VNB.t6 sky130_fd_pr__nfet_01v8 ad=0.169 pd=1.82 as=0.08775 ps=0.92 w=0.65 l=0.15
X7 a_845_297.t1 A.t1 VPWR.t1 VPB.t4 sky130_fd_pr__pfet_01v8_hvt ad=0.135 pd=1.27 as=0.3175 ps=1.635 w=1 l=0.15
X8 a_123_21.t0 C.t0 VGND.t5 VNB.t8 sky130_fd_pr__nfet_01v8 ad=0.20638 pd=1.285 as=0.25675 ps=1.44 w=0.65 l=0.15
X9 VPWR.t0 B.t3 a_845_297.t2 VPB.t5 sky130_fd_pr__pfet_01v8_hvt ad=0.3175 pd=1.635 as=0.26 ps=2.52 w=1 l=0.15
X10 a_582_297.t1 C.t2 VPWR.t4 VPB.t9 sky130_fd_pr__pfet_01v8_hvt ad=0.3175 pd=1.635 as=0.26 ps=2.52 w=1 l=0.15
X11 a_1138_21.t1 A_uq0.t1 a_1356_297.t1 VPB.t7 sky130_fd_pr__pfet_01v8_hvt ad=0.26 pd=2.52 as=0.135 ps=1.27 w=1 l=0.15
X12 a_153_297.t1 a_123_21.t4 Y.t1 VPB.t3 sky130_fd_pr__pfet_01v8_hvt ad=0.3175 pd=1.635 as=0.26 ps=2.52 w=1 l=0.15
X13 a_1138_21.t0 B.t0 VGND.t3 VNB.t5 sky130_fd_pr__nfet_01v8 ad=0.08775 pd=0.92 as=0.25675 ps=1.44 w=0.65 l=0.15
X14 a_1356_297.t0 B.t2 VPWR.t2 VPB.t6 sky130_fd_pr__pfet_01v8_hvt ad=0.135 pd=1.27 as=0.26 ps=2.52 w=1 l=0.15
X15 VGND.t1 a_256_199.t3 a_123_21.t2 VNB.t0 sky130_fd_pr__nfet_01v8 ad=0.25675 pd=1.44 as=0.20638 ps=1.285 w=0.65 l=0.15
X16 a_310_47.t0 a_256_199.t4 Y.t0 VNB.t1 sky130_fd_pr__nfet_01v8 ad=0.08775 pd=0.92 as=0.20638 ps=1.285 w=0.65 l=0.15
X17 Y.t2 a_123_21.t3 VGND.t6 VNB.t9 sky130_fd_pr__nfet_01v8 ad=0.20638 pd=1.285 as=0.169 ps=1.82 w=0.65 l=0.15
X18 a_256_199.t2 A.t0 a_927_47.t0 VNB.t3 sky130_fd_pr__nfet_01v8 ad=0.08775 pd=0.92 as=0.20638 ps=1.285 w=0.65 l=0.15
X19 VGND.t7 C.t1 a_310_47.t1 VNB.t7 sky130_fd_pr__nfet_01v8 ad=0.25675 pd=1.44 as=0.08775 ps=0.92 w=0.65 l=0.15
R0 VGND.n1 VGND.n0 9.3005
R1 VGND.n3 VGND.n2 9.3005
R2 VGND.n5 VGND.n4 9.3005
R3 VGND.n7 VGND.n6 9.3005
R4 VGND.n9 VGND.n8 9.3005
R5 VGND.n11 VGND.n10 9.3005
R6 VGND.n13 VGND.n12 9.3005
R7 VGND.n15 VGND.n14 9.3005
R8 VGND.n17 VGND.n16 9.3005
R9 VGND.n19 VGND.n18 9.3005
R10 VGND.n21 VGND.n20 9.3005
R11 VGND.n23 VGND.n22 9.3005
R12 VGND.n25 VGND.n24 9.3005
R13 VGND VGND.n34 0.0226354
R14 VGND.n34 VGND.n1 0.120292
R15 VGND.n1 VGND.n3 0.120292
R16 VGND.n3 VGND.n5 0.120292
R17 VGND.n5 VGND.n7 0.120292
R18 VGND.n7 VGND.n9 0.120292
R19 VGND.n9 VGND.n11 0.120292
R20 VGND.n11 VGND.n13 0.120292
R21 VGND.n13 VGND.n15 0.120292
R22 VGND.n15 VGND.n17 0.120292
R23 VGND.n17 VGND.n19 0.120292
R24 VGND.n19 VGND.n21 0.120292
R25 VGND.n21 VGND.n23 0.120292
R26 VGND.n23 VGND.n25 0.120292
R27 VGND.n25 VGND.n26 1.03917
R28 VGND.n26 VGND.t0 172.19
R29 VGND.n34 VGND.n33 28.124
R30 VGND.n0 VGND.n33 15.8123
R31 VGND.n0 VGND.n2 34.6358
R32 VGND.n2 VGND.n4 34.6358
R33 VGND.n4 VGND.n6 34.6358
R34 VGND.n6 VGND.n32 22.2123
R35 VGND.n8 VGND.n32 12.424
R36 VGND.n8 VGND.n10 34.6358
R37 VGND.n10 VGND.n12 34.6358
R38 VGND.n12 VGND.n14 34.6358
R39 VGND.n14 VGND.n30 13.5534
R40 VGND.n30 VGND.n16 21.0829
R41 VGND.n16 VGND.n18 34.6358
R42 VGND.n18 VGND.n20 34.6358
R43 VGND.n20 VGND.n22 34.6358
R44 VGND.n22 VGND.n24 34.6358
R45 VGND.n24 VGND.n28 1.88285
R46 VGND.n28 VGND.n26 39.4638
R47 VGND.n33 VGND.t6 290.289
R48 VGND.n32 VGND.n31 207.213
R49 VGND.n31 VGND.t7 72.9236
R50 VGND.n31 VGND.t5 72.9236
R51 VGND.n30 VGND.n29 207.213
R52 VGND.n29 VGND.t1 72.9236
R53 VGND.n29 VGND.t2 72.9236
R54 VGND.n28 VGND.n27 207.213
R55 VGND.n27 VGND.t4 72.9236
R56 VGND.n27 VGND.t3 72.9236
R57 VPWR.n2 VPWR.n1 9.3005
R58 VPWR.n4 VPWR.n3 9.3005
R59 VPWR.n6 VPWR.n5 9.3005
R60 VPWR.n8 VPWR.n7 9.3005
R61 VPWR.n10 VPWR.n9 9.3005
R62 VPWR.n12 VPWR.n11 9.3005
R63 VPWR.n14 VPWR.n13 9.3005
R64 VPWR VPWR.n0 0.357234
R65 VPWR.n0 VPWR.n2 0.147003
R66 VPWR.n2 VPWR.n4 0.120292
R67 VPWR.n4 VPWR.n6 0.120292
R68 VPWR.n6 VPWR.n8 0.120292
R69 VPWR.n8 VPWR.n10 0.120292
R70 VPWR.n10 VPWR.n12 0.120292
R71 VPWR.n12 VPWR.n14 0.120292
R72 VPWR.n14 VPWR.n15 0.268249
R73 VPWR.n15 VPWR.t2 269.716
R74 VPWR.n0 VPWR.n17 13.2484
R75 VPWR.n17 VPWR.n1 28.9887
R76 VPWR.n1 VPWR.n3 34.6358
R77 VPWR.n3 VPWR.n18 7.15344
R78 VPWR.n18 VPWR.n5 27.4829
R79 VPWR.n5 VPWR.n7 34.6358
R80 VPWR.n7 VPWR.n9 34.6358
R81 VPWR.n9 VPWR.n11 34.6358
R82 VPWR.n11 VPWR.n13 34.6358
R83 VPWR.n13 VPWR.n20 9.41227
R84 VPWR.n20 VPWR.n15 32.7036
R85 VPWR.n20 VPWR.n19 607.212
R86 VPWR.n19 VPWR.t0 63.0405
R87 VPWR.n19 VPWR.t1 62.0555
R88 VPWR.n18 VPWR.t4 347.572
R89 VPWR.n17 VPWR.n16 607.212
R90 VPWR.n16 VPWR.t3 26.5955
R91 VPWR.n16 VPWR.t5 26.5955
R92 Y.n0 Y.n1 185
R93 Y.n2 Y.n0 197.8
R94 Y.n2 Y 6.4005
R95 Y Y.n1 6.4005
R96 Y Y.n2 2.25932
R97 Y.n1 Y 88.4711
R98 Y Y.t1 232.07
R99 Y.n0 Y.t2 59.0774
R100 Y.n0 Y.t0 58.1543
R101 A_uq0 A_uq0.n0 158.4
R102 A_uq0.n0 A_uq0.t0 158.064
R103 A_uq0.n0 A_uq0.t1 230.363
R104 A A.n0 158.4
R105 A.n0 A.t0 169.237
R106 A.n0 A.t1 241.536
R107 B.n1 B.n0 152
R108 B B.n1 6.4005
R109 B.n3 B.n1 25.5479
R110 B B.n3 0.376971
R111 B.n3 B.n2 158.024
R112 B.n2 B.t0 169.237
R113 B.n2 B.t2 241.536
R114 B.n0 B.t1 158.064
R115 B.n0 B.t3 230.363
R116 C.n0 C.n1 137.298
R117 C C.n0 191.264
R118 C.n1 C.t3 212.081
R119 C.n1 C.t1 139.78
R120 C.n0 C.t2 212.081
R121 C.n0 C.t0 139.78
R122 VPB VPB.t3 322.587
R123 VPB.t3 VPB.t1 464.642
R124 VPB.t1 VPB.t8 248.599
R125 VPB.t8 VPB.t9 556.386
R126 VPB.t9 VPB.t0 464.642
R127 VPB.t0 VPB.t5 556.386
R128 VPB.t5 VPB.t4 464.642
R129 VPB.t4 VPB.t2 248.599
R130 VPB.t2 VPB.t6 556.386
R131 VPB.t6 VPB.t7 248.599
R132 VNB VNB.t9 1552.1
R133 VNB.t9 VNB.t1 2235.6
R134 VNB.t1 VNB.t7 1196.12
R135 VNB.t7 VNB.t8 2677.02
R136 VNB.t8 VNB.t0 2235.6
R137 VNB.t0 VNB.t4 2677.02
R138 VNB.t4 VNB.t3 2235.6
R139 VNB.t3 VNB.t2 1196.12
R140 VNB.t2 VNB.t5 2677.02
R141 VNB.t5 VNB.t6 1196.12
R142 a_927_47.t0 a_927_47.t1 117.231
R143 a_310_47.t0 a_310_47.t1 49.8467
R144 a_1356_297.t0 a_1356_297.t1 53.1905
R145 a_845_297.n0 a_845_297.t1 26.5955
R146 a_845_297.t0 a_845_297.n0 26.5955
R147 a_845_297.n0 a_845_297.t2 702.052
R148 a_582_297.t0 a_582_297.t1 125.096
R149 a_153_297.n0 a_153_297.t1 63.0405
R150 a_153_297.t0 a_153_297.n0 62.0555
R151 a_153_297.n0 a_153_297.t2 688.121
R152 a_1138_21.t1 a_1138_21.n0 267.952
R153 a_1138_21.n0 a_1138_21.n1 92.501
R154 a_1138_21.n0 a_1138_21.n2 231.308
R155 a_1138_21.n2 a_1138_21.t3 158.064
R156 a_1138_21.n2 a_1138_21.t4 230.363
R157 a_1138_21.n1 a_1138_21.t0 24.9236
R158 a_1138_21.n1 a_1138_21.t2 24.9236
R159 a_256_199.t1 a_256_199.n4 492.423
R160 a_256_199.n4 a_256_199.n3 54.2123
R161 a_256_199.n3 a_256_199.n2 172.707
R162 a_256_199.n2 a_256_199.t3 169.237
R163 a_256_199.n2 a_256_199.t5 241.536
R164 a_256_199.n3 a_256_199.n1 362.92
R165 a_256_199.n1 a_256_199.t4 169.237
R166 a_256_199.n1 a_256_199.t6 241.536
R167 a_256_199.n4 a_256_199.n0 180.181
R168 a_256_199.n0 a_256_199.t2 24.9236
R169 a_256_199.n0 a_256_199.t0 24.9236
R170 a_123_21.t1 a_123_21.n0 280.438
R171 a_123_21.n0 a_123_21.n2 336.003
R172 a_123_21.n2 a_123_21.t3 158.064
R173 a_123_21.n2 a_123_21.t4 230.363
R174 a_123_21.n0 a_123_21.n1 210.081
R175 a_123_21.n1 a_123_21.t0 58.1543
R176 a_123_21.n1 a_123_21.t2 59.0774
C0 VGND VPWR 0.05778f
C1 VGND C 0.03257f
C2 A VPWR 0.01272f
C3 Y VPB 0.01625f
C4 B VPB 0.08402f
C5 A_uq0 B 0.03088f
C6 A VGND 0.01021f
C7 Y VPWR 0.03338f
C8 B VPWR 0.08828f
C9 C Y 0.00298f
C10 A_uq0 VPB 0.03988f
C11 VGND Y 0.07366f
C12 VPWR VPB 0.24832f
C13 VGND B 0.0786f
C14 C VPB 0.10419f
C15 A B 0.04306f
C16 A_uq0 VPWR 0.01586f
C17 VGND VPB 0.0211f
C18 C VPWR 0.03943f
C19 A VPB 0.03003f
C20 VGND A_uq0 0.03339f
C21 VGND VNB 0.94005f
C22 VPWR VNB 0.77043f
C23 Y VNB 0.14583f
C24 A_uq0 VNB 0.12473f
C25 A VNB 0.08177f
C26 B VNB 0.17055f
C27 C VNB 0.21627f
C28 VPB VNB 1.63934f
C29 a_123_21.t1 VNB 0.12899f
C30 a_123_21.n0 VNB 0.30823f
C31 a_123_21.t0 VNB 0.04949f
C32 a_123_21.t2 VNB 0.05476f
C33 a_123_21.n1 VNB 0.07186f
C34 a_123_21.n2 VNB 0.11478f
C35 a_256_199.t1 VNB 0.15778f
C36 a_256_199.n0 VNB 0.08194f
C37 a_256_199.t2 VNB 0.03903f
C38 a_256_199.t0 VNB 0.0328f
C39 a_256_199.n1 VNB 0.12732f
C40 a_256_199.n2 VNB 0.06221f
C41 a_256_199.n3 VNB 0.22216f
C42 a_256_199.n4 VNB 0.2685f
C43 a_1138_21.t1 VNB 0.12073f
C44 a_1138_21.n0 VNB 0.25799f
C45 a_1138_21.n1 VNB 0.02597f
C46 a_1138_21.t0 VNB 0.03485f
C47 a_1138_21.t2 VNB 0.03049f
C48 a_1138_21.n2 VNB 0.07619f
C49 a_153_297.t0 VNB 0.06044f
C50 a_153_297.n0 VNB 0.11238f
C51 a_153_297.t2 VNB 0.11841f
C52 a_153_297.t1 VNB 0.05544f
C53 a_582_297.t0 VNB 0.06421f
C54 a_582_297.t1 VNB 0.05838f
C55 a_845_297.t0 VNB 0.04002f
C56 a_845_297.n0 VNB 0.10991f
C57 a_845_297.t2 VNB 0.16463f
C58 a_845_297.t1 VNB 0.0486f
C59 a_1356_297.t0 VNB 0.04663f
C60 a_1356_297.t1 VNB 0.04064f
C61 a_310_47.t0 VNB 0.03181f
C62 a_310_47.t1 VNB 0.02707f
C63 a_927_47.t0 VNB 0.04474f
C64 a_927_47.t1 VNB 0.04455f
C65 VPB.t0 VNB 0.08522f
C66 VPB.t1 VNB 0.05953f
C67 VPB.t2 VNB 0.06719f
C68 VPB.t3 VNB 0.0657f
C69 VPB.t4 VNB 0.05953f
C70 VPB.t5 VNB 0.08522f
C71 VPB.t6 VNB 0.06719f
C72 VPB.t7 VNB 0.10819f
C73 VPB.t8 VNB 0.06719f
C74 VPB.t9 VNB 0.08522f
C75 C.n0 VNB 0.11354f
C76 C.n1 VNB 0.08668f
C77 B.n0 VNB 0.08456f
C78 B.n1 VNB 0.08225f
C79 B.n2 VNB 0.06184f
C80 B.n3 VNB 0.13172f
C81 A.n0 VNB 0.06149f
C82 A_uq0.n0 VNB 0.06937f
C83 Y.n0 VNB 0.03813f
C84 Y.t2 VNB 0.03647f
C85 Y.t0 VNB 0.04018f
C86 Y.n1 VNB 0.02358f
C87 Y.t1 VNB 0.07004f
C88 Y.n2 VNB 0.02806f
C89 VPWR.n0 VNB 0.08219f
C90 VPWR.n1 VNB 0.01099f
C91 VPWR.n2 VNB 0.0412f
C92 VPWR.n3 VNB 0.00722f
C93 VPWR.n4 VNB 0.03378f
C94 VPWR.n5 VNB 0.01073f
C95 VPWR.n6 VNB 0.03378f
C96 VPWR.n7 VNB 0.01196f
C97 VPWR.n8 VNB 0.03378f
C98 VPWR.n9 VNB 0.01196f
C99 VPWR.n10 VNB 0.03378f
C100 VPWR.n11 VNB 0.01196f
C101 VPWR.n12 VNB 0.03378f
C102 VPWR.n13 VNB 0.00761f
C103 VPWR.n14 VNB 0.14269f
C104 VPWR.n15 VNB 0.18808f
C105 VPWR.t3 VNB 0.03997f
C106 VPWR.t5 VNB 0.03415f
C107 VPWR.n16 VNB 0.02095f
C108 VPWR.n17 VNB 0.02315f
C109 VPWR.t4 VNB 0.06275f
C110 VPWR.n18 VNB 0.02765f
C111 VPWR.t0 VNB 0.0547f
C112 VPWR.t1 VNB 0.05453f
C113 VPWR.n19 VNB 0.04888f
C114 VPWR.n20 VNB 0.02051f
C115 VPWR.t2 VNB 0.07307f
C116 VGND.n0 VNB 0.00605f
C117 VGND.n1 VNB 0.02345f
C118 VGND.n2 VNB 0.00831f
C119 VGND.n3 VNB 0.02345f
C120 VGND.n4 VNB 0.00831f
C121 VGND.n5 VNB 0.02345f
C122 VGND.n6 VNB 0.00682f
C123 VGND.n7 VNB 0.02345f
C124 VGND.n8 VNB 0.00564f
C125 VGND.n9 VNB 0.02345f
C126 VGND.n10 VNB 0.00831f
C127 VGND.n11 VNB 0.02345f
C128 VGND.n12 VNB 0.00831f
C129 VGND.n13 VNB 0.02345f
C130 VGND.n14 VNB 0.00578f
C131 VGND.n15 VNB 0.02345f
C132 VGND.n16 VNB 0.00668f
C133 VGND.n17 VNB 0.02345f
C134 VGND.n18 VNB 0.00831f
C135 VGND.n19 VNB 0.02345f
C136 VGND.n20 VNB 0.00831f
C137 VGND.n21 VNB 0.02345f
C138 VGND.n22 VNB 0.00831f
C139 VGND.n23 VNB 0.02345f
C140 VGND.n24 VNB 0.00438f
C141 VGND.n25 VNB 0.08838f
C142 VGND.n26 VNB 0.04259f
C143 VGND.t0 VNB 0.03625f
C144 VGND.t4 VNB 0.0294f
C145 VGND.t3 VNB 0.03577f
C146 VGND.n27 VNB 0.02788f
C147 VGND.n28 VNB 0.0133f
C148 VGND.t1 VNB 0.03507f
C149 VGND.t2 VNB 0.03544f
C150 VGND.n29 VNB 0.02788f
C151 VGND.n30 VNB 0.01185f
C152 VGND.t7 VNB 0.03032f
C153 VGND.t5 VNB 0.03032f
C154 VGND.n31 VNB 0.02788f
C155 VGND.n32 VNB 0.01185f
C156 VGND.t6 VNB 0.03396f
C157 VGND.n33 VNB 0.016f
C158 VGND.n34 VNB 0.01818f
.ends
