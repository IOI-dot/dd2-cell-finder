* NGSPICE file created from a_xor3_r3.ext - technology: sky130A

.subckt a_xor3_r3 A B C Y VGND VPWR VPB VNB A_uq0
X0 a_153_297# C VPWR VPB sky130_fd_pr__pfet_01v8_hvt ad=0.26 pd=2.52 as=0.135 ps=1.27 w=1 l=0.15
X1 a_927_47# B VGND VNB sky130_fd_pr__nfet_01v8 ad=0.20638 pd=1.285 as=0.25675 ps=1.44 w=0.65 l=0.15
X2 VPWR a_256_199# a_153_297# VPB sky130_fd_pr__pfet_01v8_hvt ad=0.135 pd=1.27 as=0.3175 ps=1.635 w=1 l=0.15
X3 VGND a_1138_21# a_256_199# VNB sky130_fd_pr__nfet_01v8 ad=0.25675 pd=1.44 as=0.08775 ps=0.92 w=0.65 l=0.15
X4 a_256_199# a_1138_21# a_845_297# VPB sky130_fd_pr__pfet_01v8_hvt ad=0.26 pd=2.52 as=0.135 ps=1.27 w=1 l=0.15
X5 a_123_21# a_256_199# a_582_297# VPB sky130_fd_pr__pfet_01v8_hvt ad=0.26 pd=2.52 as=0.3175 ps=1.635 w=1 l=0.15
X6 VGND A_uq0 a_1138_21# VNB sky130_fd_pr__nfet_01v8 ad=0.169 pd=1.82 as=0.08775 ps=0.92 w=0.65 l=0.15
X7 a_845_297# A VPWR VPB sky130_fd_pr__pfet_01v8_hvt ad=0.135 pd=1.27 as=0.3175 ps=1.635 w=1 l=0.15
X8 a_123_21# C VGND VNB sky130_fd_pr__nfet_01v8 ad=0.20638 pd=1.285 as=0.25675 ps=1.44 w=0.65 l=0.15
X9 VPWR B a_845_297# VPB sky130_fd_pr__pfet_01v8_hvt ad=0.3175 pd=1.635 as=0.26 ps=2.52 w=1 l=0.15
X10 a_582_297# C VPWR VPB sky130_fd_pr__pfet_01v8_hvt ad=0.3175 pd=1.635 as=0.26 ps=2.52 w=1 l=0.15
X11 a_1138_21# A_uq0 a_1356_297# VPB sky130_fd_pr__pfet_01v8_hvt ad=0.26 pd=2.52 as=0.135 ps=1.27 w=1 l=0.15
X12 a_153_297# a_123_21# Y VPB sky130_fd_pr__pfet_01v8_hvt ad=0.3175 pd=1.635 as=0.26 ps=2.52 w=1 l=0.15
X13 a_1138_21# B VGND VNB sky130_fd_pr__nfet_01v8 ad=0.08775 pd=0.92 as=0.25675 ps=1.44 w=0.65 l=0.15
X14 a_1356_297# B VPWR VPB sky130_fd_pr__pfet_01v8_hvt ad=0.135 pd=1.27 as=0.26 ps=2.52 w=1 l=0.15
X15 VGND a_256_199# a_123_21# VNB sky130_fd_pr__nfet_01v8 ad=0.25675 pd=1.44 as=0.20638 ps=1.285 w=0.65 l=0.15
X16 a_310_47# a_256_199# Y VNB sky130_fd_pr__nfet_01v8 ad=0.08775 pd=0.92 as=0.20638 ps=1.285 w=0.65 l=0.15
X17 Y a_123_21# VGND VNB sky130_fd_pr__nfet_01v8 ad=0.20638 pd=1.285 as=0.169 ps=1.82 w=0.65 l=0.15
X18 a_256_199# A a_927_47# VNB sky130_fd_pr__nfet_01v8 ad=0.08775 pd=0.92 as=0.20638 ps=1.285 w=0.65 l=0.15
X19 VGND C a_310_47# VNB sky130_fd_pr__nfet_01v8 ad=0.25675 pd=1.44 as=0.08775 ps=0.92 w=0.65 l=0.15
.ends
