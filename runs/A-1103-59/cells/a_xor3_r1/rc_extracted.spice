* NGSPICE file created from a_xor3_r1.ext - technology: sky130A

.subckt a_xor3_r1 A B C VGND VNB VPB VPWR Y
X0 a_804_297.t2 A.t3 VPWR.t0 VPB.t6 sky130_fd_pr__pfet_01v8_hvt ad=0.4 pd=1.8 as=0.135 ps=1.27 w=1 l=0.15 sa=0.68 sb=1.21
X1 VGND.t7 a_666_21# a_392_21.t1 VNB.t8 sky130_fd_pr__nfet_01v8 ad=0.26 pd=1.45 as=0.08775 ps=0.92 w=0.65 l=0.15 sa=3 sb=4.47
X2 a_1348_297.t0 B.t2 VPWR.t3 VPB.t3 sky130_fd_pr__pfet_01v8_hvt ad=0.4 pd=1.8 as=0.26 ps=2.52 w=1 l=0.15 sa=0.26 sb=1.21
X3 VPWR.t2 B.t3 a_804_297.t1 VPB.t2 sky130_fd_pr__pfet_01v8_hvt ad=0.135 pd=1.27 as=0.26 ps=2.52 w=1 l=0.15 sa=0.26 sb=1.63
X4 a_970_47.t0 A.t1 a_886_47.t1 VNB.t5 sky130_fd_pr__nfet_01v8 ad=0.26 pd=1.45 as=0.08775 ps=0.92 w=0.65 l=0.15 sa=4.37 sb=3.1
X5 a_1073_199.t0 B.t0 VGND.t3 VNB.t2 sky130_fd_pr__nfet_01v8 ad=0.26 pd=1.45 as=0.25675 ps=1.44 w=0.65 l=0.15 sa=6.26 sb=1.21
X6 a_66_297.t2 a_251_199# VPWR.t5 VPB.t9 sky130_fd_pr__pfet_01v8_hvt ad=0.135 pd=1.27 as=0.4 ps=1.8 w=1 l=0.15 sa=1.21 sb=0.68
X7 a_148_47.t0 C.t1 VGND.t5 VNB.t3 sky130_fd_pr__nfet_01v8 ad=0.26 pd=1.45 as=0.169 ps=1.82 w=0.65 l=0.15 sa=0.26 sb=7.21
X8 a_886_47.t0 B.t1 VGND.t2 VNB.t1 sky130_fd_pr__nfet_01v8 ad=0.08775 pd=0.92 as=0.26 ps=1.45 w=0.65 l=0.15 sa=3.95 sb=3.52
X9 VGND.t6 a_1073_199.t3 a_970_47.t1 VNB.t7 sky130_fd_pr__nfet_01v8 ad=0.25675 pd=1.44 as=0.26 ps=1.45 w=0.65 l=0.15 sa=5.32 sb=2.15
X10 a_392_21.t2 a_666_21# a_612_297.t1 VPB.t8 sky130_fd_pr__pfet_01v8_hvt ad=0.26 pd=2.52 as=0.135 ps=1.27 w=1 l=0.15 sa=0.68 sb=0.26
X11 VGND.t0 a_392_21.t3 Y.t0 VNB.t0 sky130_fd_pr__nfet_01v8 ad=0.26 pd=1.45 as=0.08775 ps=0.92 w=0.65 l=0.15 sa=1.63 sb=5.84
X12 VGND.t1 A.t0 a_1073_199.t2 VNB.t6 sky130_fd_pr__nfet_01v8 ad=0.169 pd=1.82 as=0.26 ps=1.45 w=0.65 l=0.15 sa=7.21 sb=0.26
X13 a_612_297.t0 C.t2 VPWR.t4 VPB.t5 sky130_fd_pr__pfet_01v8_hvt ad=0.135 pd=1.27 as=0.26 ps=2.52 w=1 l=0.15 sa=0.26 sb=0.68
X14 VPWR.t1 C.t3 a_66_297.t1 VPB.t4 sky130_fd_pr__pfet_01v8_hvt ad=0.4 pd=1.8 as=0.26 ps=2.52 w=1 l=0.15 sa=0.26 sb=1.63
X15 Y.t2 a_251_199# a_148_47.t1 VNB.t9 sky130_fd_pr__nfet_01v8 ad=0.08775 pd=0.92 as=0.26 ps=1.45 w=0.65 l=0.15 sa=1.21 sb=6.26
X16 a_1160_297# a_1073_199.t4 a_804_297.t0 VPB.t1 sky130_fd_pr__pfet_01v8_hvt ad=0.26 pd=2.52 as=0.4 ps=1.8 w=1 l=0.15 sa=1.63 sb=0.26
X17 a_1073_199.t1 A.t2 a_1348_297.t1 VPB.t7 sky130_fd_pr__pfet_01v8_hvt ad=0.26 pd=2.52 as=0.4 ps=1.8 w=1 l=0.15 sa=1.21 sb=0.26
X18 a_392_21.t0 C.t0 VGND.t4 VNB.t4 sky130_fd_pr__nfet_01v8 ad=0.08775 pd=0.92 as=0.26 ps=1.45 w=0.65 l=0.15 sa=2.58 sb=4.89
X19 Y.t1 a_392_21.t4 a_66_297.t0 VPB.t0 sky130_fd_pr__pfet_01v8_hvt ad=0.26 pd=2.52 as=0.135 ps=1.27 w=1 l=0.15 sa=1.63 sb=0.26
R0 VGND.n1 VGND.n0 9.3005
R1 VGND.n3 VGND.n2 9.3005
R2 VGND.n5 VGND.n4 9.3005
R3 VGND.n7 VGND.n6 9.3005
R4 VGND.n9 VGND.n8 9.3005
R5 VGND.n11 VGND.n10 9.3005
R6 VGND.n13 VGND.n12 9.3005
R7 VGND.n15 VGND.n14 9.3005
R8 VGND.n17 VGND.n16 9.3005
R9 VGND.n19 VGND.n18 9.3005
R10 VGND.n21 VGND.n20 9.3005
R11 VGND.n23 VGND.n22 9.3005
R12 VGND VGND.n32 0.0226354
R13 VGND.n32 VGND.n1 0.120292
R14 VGND.n1 VGND.n3 0.120292
R15 VGND.n3 VGND.n5 0.120292
R16 VGND.n5 VGND.n7 0.120292
R17 VGND.n7 VGND.n9 0.120292
R18 VGND.n9 VGND.n11 0.120292
R19 VGND.n11 VGND.n13 0.120292
R20 VGND.n13 VGND.n15 0.120292
R21 VGND.n15 VGND.n17 0.120292
R22 VGND.n17 VGND.n19 0.120292
R23 VGND.n19 VGND.n21 0.120292
R24 VGND.n21 VGND.n23 0.120292
R25 VGND.n23 VGND.n24 0.173777
R26 VGND.n24 VGND.t1 303.486
R27 VGND.n32 VGND.n31 26.2417
R28 VGND.n31 VGND.n0 17.6946
R29 VGND.n0 VGND.n2 34.6358
R30 VGND.n2 VGND.n4 34.6358
R31 VGND.n4 VGND.n6 34.6358
R32 VGND.n6 VGND.n30 33.1299
R33 VGND.n8 VGND.n30 1.50638
R34 VGND.n8 VGND.n10 34.6358
R35 VGND.n10 VGND.n12 34.6358
R36 VGND.n12 VGND.n28 32.377
R37 VGND.n14 VGND.n28 2.25932
R38 VGND.n14 VGND.n16 34.6358
R39 VGND.n16 VGND.n18 34.6358
R40 VGND.n18 VGND.n20 34.6358
R41 VGND.n20 VGND.n22 34.6358
R42 VGND.n22 VGND.n26 33.5064
R43 VGND.n24 VGND.n26 8.70394
R44 VGND.n31 VGND.t5 160.222
R45 VGND.n30 VGND.n29 207.213
R46 VGND.n29 VGND.t0 73.8467
R47 VGND.n29 VGND.t4 73.8467
R48 VGND.n28 VGND.n27 120.698
R49 VGND.n27 VGND.t7 73.8467
R50 VGND.n27 VGND.t2 73.8467
R51 VGND.n26 VGND.n25 207.213
R52 VGND.n25 VGND.t6 72.9236
R53 VGND.n25 VGND.t3 72.9236
R54 Y.n1 Y.n0 185
R55 Y.n0 Y 194.892
R56 Y Y.n1 3.29747
R57 Y.n2 Y.n1 20.0244
R58 Y Y.n2 0.376971
R59 Y.n2 Y.t1 331.384
R60 Y.n0 Y.t2 24.9236
R61 Y.n0 Y.t0 24.9236
R62 VPWR.n2 VPWR.n1 9.3005
R63 VPWR.n4 VPWR.n3 9.3005
R64 VPWR.n6 VPWR.n5 9.3005
R65 VPWR.n8 VPWR.n7 9.3005
R66 VPWR.n10 VPWR.n9 9.3005
R67 VPWR.n12 VPWR.n11 9.3005
R68 VPWR.n14 VPWR.n13 9.3005
R69 VPWR.n16 VPWR.n15 9.3005
R70 VPWR VPWR.n0 0.121778
R71 VPWR.n0 VPWR.n2 0.141672
R72 VPWR.n2 VPWR.n4 0.120292
R73 VPWR.n4 VPWR.n6 0.120292
R74 VPWR.n6 VPWR.n8 0.120292
R75 VPWR.n8 VPWR.n10 0.120292
R76 VPWR.n10 VPWR.n12 0.120292
R77 VPWR.n12 VPWR.n14 0.120292
R78 VPWR.n14 VPWR.n16 0.120292
R79 VPWR.n16 VPWR.n17 0.172128
R80 VPWR.n17 VPWR.t3 888.957
R81 VPWR.n0 VPWR.n19 41.5414
R82 VPWR.n1 VPWR.n19 0.753441
R83 VPWR.n1 VPWR.n3 34.6358
R84 VPWR.n3 VPWR.n5 34.6358
R85 VPWR.n5 VPWR.n7 34.6358
R86 VPWR.n7 VPWR.n20 18.4476
R87 VPWR.n9 VPWR.n20 16.1887
R88 VPWR.n9 VPWR.n11 34.6358
R89 VPWR.n11 VPWR.n13 34.6358
R90 VPWR.n13 VPWR.n15 34.6358
R91 VPWR.n15 VPWR.n22 14.6829
R92 VPWR.n22 VPWR.n17 27.5291
R93 VPWR.n22 VPWR.n21 607.212
R94 VPWR.n21 VPWR.t2 26.5955
R95 VPWR.n21 VPWR.t0 26.5955
R96 VPWR.n20 VPWR.t4 257.474
R97 VPWR.n19 VPWR.n18 607.212
R98 VPWR.n18 VPWR.t1 78.8005
R99 VPWR.n18 VPWR.t5 78.8005
R100 A.n1 A.n0 152
R101 A A.n1 6.4005
R102 A.n3 A.n1 25.836
R103 A A.n3 0.376971
R104 A.n3 A.n2 158.024
R105 A.n2 A.t0 158.064
R106 A.n2 A.t2 230.363
R107 A.n0 A.t1 158.064
R108 A.n0 A.t3 230.363
R109 B.n1 B.n0 152
R110 B B.n1 6.4005
R111 B B.n1 277.459
R112 B B.n2 158.4
R113 B.n2 B.t0 158.064
R114 B.n2 B.t2 230.363
R115 B.n0 B.t1 158.064
R116 B.n0 B.t3 230.363
R117 C.n1 C.n0 152
R118 C C.n1 6.4005
R119 C.n3 C.n1 25.5534
R120 C C.n3 0.376971
R121 C.n3 C.n2 158.024
R122 C.n2 C.t0 158.064
R123 C.n2 C.t2 230.363
R124 C.n0 C.t1 158.064
R125 C.n0 C.t3 230.363
R126 VPB VPB.t4 307.788
R127 VPB.t4 VPB.t9 562.306
R128 VPB.t9 VPB.t0 248.599
R129 VPB.t0 VPB.t5 562.306
R130 VPB.t5 VPB.t8 248.599
R131 VPB.t8 VPB.t2 562.306
R132 VPB.t2 VPB.t6 248.599
R133 VPB.t6 VPB.t1 562.306
R134 VPB.t1 VPB.t3 556.386
R135 VPB.t3 VPB.t7 562.306
R136 VNB VNB.t3 1480.91
R137 VNB.t3 VNB.t9 2705.5
R138 VNB.t9 VNB.t0 1196.12
R139 VNB.t0 VNB.t4 2705.5
R140 VNB.t4 VNB.t8 1196.12
R141 VNB.t8 VNB.t1 2705.5
R142 VNB.t1 VNB.t5 1196.12
R143 VNB.t5 VNB.t7 2705.5
R144 VNB.t7 VNB.t2 2677.02
R145 VNB.t2 VNB.t6 2705.5
R146 a_970_47.t0 a_970_47.t1 147.692
R147 a_886_47.t0 a_886_47.t1 49.8467
R148 a_148_47.t0 a_148_47.t1 147.692
R149 a_1348_297.t0 a_1348_297.t1 157.601
R150 a_804_297.n0 a_804_297.t2 78.8005
R151 a_804_297.t0 a_804_297.n0 78.8005
R152 a_804_297.n0 a_804_297.t1 489.3
R153 a_612_297.t0 a_612_297.t1 53.1905
R154 a_66_297.n0 a_66_297.t2 26.5955
R155 a_66_297.t0 a_66_297.n0 26.5955
R156 a_66_297.n0 a_66_297.t1 509.253
R157 a_1073_199.t1 a_1073_199.n1 228.773
R158 a_1073_199.n1 a_1073_199.n2 196.279
R159 a_1073_199.n2 a_1073_199.t0 73.8467
R160 a_1073_199.n2 a_1073_199.t2 73.8467
R161 a_1073_199.n1 a_1073_199.n0 339.483
R162 a_1073_199.n0 a_1073_199.t3 158.064
R163 a_1073_199.n0 a_1073_199.t4 230.363
R164 a_392_21.t2 a_392_21.n2 302.901
R165 a_392_21.n2 a_392_21.n0 99.3308
R166 a_392_21.n2 a_392_21.n1 221.556
R167 a_392_21.n1 a_392_21.t3 158.064
R168 a_392_21.n1 a_392_21.t4 230.363
R169 a_392_21.n0 a_392_21.t0 24.9236
R170 a_392_21.n0 a_392_21.t1 24.9236
C0 C VPWR 0.07909f
C1 a_1160_297# VPB 0.00734f
C2 VGND VPB 0.02113f
C3 B A 0.13359f
C4 a_666_21# A 0
C5 a_251_199# C 0.04526f
C6 Y A 0.00431f
C7 a_666_21# C 0.02548f
C8 a_251_199# VPWR 0.01459f
C9 C Y 0.12983f
C10 a_1160_297# A 0.00885f
C11 B VPWR 0.03578f
C12 a_666_21# VPWR 0.01665f
C13 VPWR Y 0.07891f
C14 VPB A 0.09158f
C15 VGND A 0.08727f
C16 VPB C 0.08917f
C17 a_1160_297# VPWR 0.03951f
C18 VGND C 0.0596f
C19 a_251_199# Y 0.00885f
C20 VPB VPWR 0.25938f
C21 VGND VPWR 0.04195f
C22 a_666_21# B 0.02476f
C23 B Y 0.00489f
C24 a_666_21# Y 0.00735f
C25 a_251_199# VPB 0.03925f
C26 a_1160_297# B 0.00189f
C27 a_1160_297# Y 0
C28 a_251_199# VGND 0.01794f
C29 B VPB 0.08566f
C30 a_666_21# VPB 0.03956f
C31 VPWR A 0.07195f
C32 VPB Y 0.02553f
C33 VGND B 0.20713f
C34 a_666_21# VGND 0.02899f
C35 VGND Y 0.10789f
C36 VGND VNB 0f
C37 Y VNB 0f
C38 VPWR VNB 0f
C39 A VNB 0f
C40 B VNB 0.04352f
C41 C VNB 0f
C42 VPB VNB 0.94709f
C43 a_1160_297# VNB 0.0209f
C44 a_392_21.t2 VNB 0.1179f
C45 a_392_21.n0 VNB 0.03412f
C46 a_392_21.t0 VNB 0.03667f
C47 a_392_21.t1 VNB 0.05449f
C48 a_392_21.n1 VNB 0.08765f
C49 a_392_21.n2 VNB 0.24883f
C50 a_1073_199.t1 VNB 0.09719f
C51 a_1073_199.n0 VNB 0.09623f
C52 a_1073_199.n1 VNB 0.24038f
C53 a_1073_199.n2 VNB 0.11133f
C54 a_1073_199.t0 VNB 0.05833f
C55 a_1073_199.t2 VNB 0.05705f
C56 a_66_297.t0 VNB 0.04186f
C57 a_66_297.n0 VNB 0.12521f
C58 a_66_297.t1 VNB 0.17063f
C59 a_66_297.t2 VNB 0.05557f
C60 a_612_297.t0 VNB 0.04544f
C61 a_612_297.t1 VNB 0.0156f
C62 a_804_297.t0 VNB 0.05552f
C63 a_804_297.n0 VNB 0.13553f
C64 a_804_297.t1 VNB 0.1325f
C65 a_804_297.t2 VNB 0.06483f
C66 a_1348_297.t0 VNB 0.07527f
C67 a_1348_297.t1 VNB 0.0735f
C68 a_148_47.t0 VNB 0.05458f
C69 a_148_47.t1 VNB 0.03305f
C70 a_886_47.t0 VNB 0.03022f
C71 a_886_47.t1 VNB 0.02895f
C72 a_970_47.t0 VNB 0.06601f
C73 a_970_47.t1 VNB 0.05929f
C74 VPB.t0 VNB 0.0661f
C75 VPB.t1 VNB 0.09119f
C76 VPB.t2 VNB 0.0661f
C77 VPB.t3 VNB 0.09119f
C78 VPB.t4 VNB 0.07093f
C79 VPB.t5 VNB 0.0661f
C80 VPB.t6 VNB 0.0661f
C81 VPB.t7 VNB 0.12834f
C82 VPB.t8 VNB 0.0661f
C83 VPB.t9 VNB 0.0661f
C84 C.n0 VNB 0.08349f
C85 C.n1 VNB 0.08156f
C86 C.n2 VNB 0.08402f
C87 C.n3 VNB 0.13062f
C88 B.n0 VNB 0.08858f
C89 B.n1 VNB 0.14892f
C90 B.n2 VNB 0.08918f
C91 A.n0 VNB 0.08362f
C92 A.n1 VNB 0.10012f
C93 A.n2 VNB 0.08415f
C94 A.n3 VNB 0.1598f
C95 VPWR.n0 VNB 0.04453f
C96 VPWR.n1 VNB 0.00595f
C97 VPWR.n2 VNB 0.03786f
C98 VPWR.n3 VNB 0.01164f
C99 VPWR.n4 VNB 0.03288f
C100 VPWR.n5 VNB 0.01164f
C101 VPWR.n6 VNB 0.03288f
C102 VPWR.n7 VNB 0.00892f
C103 VPWR.n8 VNB 0.03288f
C104 VPWR.n9 VNB 0.00854f
C105 VPWR.n10 VNB 0.03288f
C106 VPWR.n11 VNB 0.01164f
C107 VPWR.n12 VNB 0.03288f
C108 VPWR.n13 VNB 0.01164f
C109 VPWR.n14 VNB 0.03288f
C110 VPWR.n15 VNB 0.00829f
C111 VPWR.n16 VNB 0.0837f
C112 VPWR.n17 VNB 0.31445f
C113 VPWR.t1 VNB 0.05962f
C114 VPWR.t5 VNB 0.0695f
C115 VPWR.n18 VNB 0.05985f
C116 VPWR.n19 VNB 0.01975f
C117 VPWR.t4 VNB 0.06912f
C118 VPWR.n20 VNB 0.03411f
C119 VPWR.t2 VNB 0.04171f
C120 VPWR.t0 VNB 0.03994f
C121 VPWR.n21 VNB 0.02039f
C122 VPWR.n22 VNB 0.02037f
C123 VPWR.t3 VNB 0.06725f
C124 Y.n0 VNB 0.03377f
C125 Y.t2 VNB 0.01623f
C126 Y.t0 VNB 0.03499f
C127 Y.n1 VNB 0.14901f
C128 Y.t1 VNB 0.11787f
C129 Y.n2 VNB 0.17486f
C130 VGND.n0 VNB 0.00635f
C131 VGND.n1 VNB 0.02373f
C132 VGND.n2 VNB 0.00841f
C133 VGND.n3 VNB 0.02373f
C134 VGND.n4 VNB 0.00841f
C135 VGND.n5 VNB 0.02373f
C136 VGND.n6 VNB 0.00822f
C137 VGND.n7 VNB 0.02373f
C138 VGND.n8 VNB 0.00439f
C139 VGND.n9 VNB 0.02373f
C140 VGND.n10 VNB 0.00841f
C141 VGND.n11 VNB 0.02373f
C142 VGND.n12 VNB 0.00813f
C143 VGND.n13 VNB 0.02373f
C144 VGND.n14 VNB 0.00448f
C145 VGND.n15 VNB 0.02373f
C146 VGND.n16 VNB 0.00841f
C147 VGND.n17 VNB 0.02373f
C148 VGND.n18 VNB 0.00841f
C149 VGND.n19 VNB 0.02373f
C150 VGND.n20 VNB 0.00841f
C151 VGND.n21 VNB 0.02373f
C152 VGND.n22 VNB 0.00827f
C153 VGND.n23 VNB 0.04725f
C154 VGND.n24 VNB 0.13676f
C155 VGND.t1 VNB 0.0392f
C156 VGND.t6 VNB 0.02865f
C157 VGND.t3 VNB 0.03664f
C158 VGND.n25 VNB 0.02821f
C159 VGND.n26 VNB 0.01729f
C160 VGND.n27 VNB 0.03075f
C161 VGND.t7 VNB 0.05333f
C162 VGND.t2 VNB 0.03682f
C163 VGND.n28 VNB 0.01602f
C164 VGND.t0 VNB 0.03274f
C165 VGND.t4 VNB 0.03551f
C166 VGND.n29 VNB 0.02856f
C167 VGND.n30 VNB 0.012f
C168 VGND.t5 VNB 0.03854f
C169 VGND.n31 VNB 0.0222f
C170 VGND.n32 VNB 0.0181f
.ends
