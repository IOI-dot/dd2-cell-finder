* NGSPICE file created from a_xor3_r1.ext - technology: sky130A

.subckt a_xor3_r1 A B C VGND VNB VPB VPWR Y
X0 a_804_297# A VPWR VPB sky130_fd_pr__pfet_01v8_hvt ad=0.4 pd=1.8 as=0.135 ps=1.27 w=1 l=0.15
X1 VGND a_666_21# a_392_21# VNB sky130_fd_pr__nfet_01v8 ad=0.26 pd=1.45 as=0.08775 ps=0.92 w=0.65 l=0.15
X2 a_1348_297# B VPWR VPB sky130_fd_pr__pfet_01v8_hvt ad=0.4 pd=1.8 as=0.26 ps=2.52 w=1 l=0.15
X3 VPWR B a_804_297# VPB sky130_fd_pr__pfet_01v8_hvt ad=0.135 pd=1.27 as=0.26 ps=2.52 w=1 l=0.15
X4 a_970_47# A a_886_47# VNB sky130_fd_pr__nfet_01v8 ad=0.26 pd=1.45 as=0.08775 ps=0.92 w=0.65 l=0.15
X5 a_1073_199# B VGND VNB sky130_fd_pr__nfet_01v8 ad=0.26 pd=1.45 as=0.25675 ps=1.44 w=0.65 l=0.15
X6 a_66_297# a_251_199# VPWR VPB sky130_fd_pr__pfet_01v8_hvt ad=0.135 pd=1.27 as=0.4 ps=1.8 w=1 l=0.15
X7 a_148_47# C VGND VNB sky130_fd_pr__nfet_01v8 ad=0.26 pd=1.45 as=0.169 ps=1.82 w=0.65 l=0.15
X8 a_886_47# B VGND VNB sky130_fd_pr__nfet_01v8 ad=0.08775 pd=0.92 as=0.26 ps=1.45 w=0.65 l=0.15
X9 VGND a_1073_199# a_970_47# VNB sky130_fd_pr__nfet_01v8 ad=0.25675 pd=1.44 as=0.26 ps=1.45 w=0.65 l=0.15
X10 a_392_21# a_666_21# a_612_297# VPB sky130_fd_pr__pfet_01v8_hvt ad=0.26 pd=2.52 as=0.135 ps=1.27 w=1 l=0.15
X11 VGND a_392_21# Y VNB sky130_fd_pr__nfet_01v8 ad=0.26 pd=1.45 as=0.08775 ps=0.92 w=0.65 l=0.15
X12 VGND A a_1073_199# VNB sky130_fd_pr__nfet_01v8 ad=0.169 pd=1.82 as=0.26 ps=1.45 w=0.65 l=0.15
X13 a_612_297# C VPWR VPB sky130_fd_pr__pfet_01v8_hvt ad=0.135 pd=1.27 as=0.26 ps=2.52 w=1 l=0.15
X14 VPWR C a_66_297# VPB sky130_fd_pr__pfet_01v8_hvt ad=0.4 pd=1.8 as=0.26 ps=2.52 w=1 l=0.15
X15 Y a_251_199# a_148_47# VNB sky130_fd_pr__nfet_01v8 ad=0.08775 pd=0.92 as=0.26 ps=1.45 w=0.65 l=0.15
X16 a_1160_297# a_1073_199# a_804_297# VPB sky130_fd_pr__pfet_01v8_hvt ad=0.26 pd=2.52 as=0.4 ps=1.8 w=1 l=0.15
X17 a_1073_199# A a_1348_297# VPB sky130_fd_pr__pfet_01v8_hvt ad=0.26 pd=2.52 as=0.4 ps=1.8 w=1 l=0.15
X18 a_392_21# C VGND VNB sky130_fd_pr__nfet_01v8 ad=0.08775 pd=0.92 as=0.26 ps=1.45 w=0.65 l=0.15
X19 Y a_392_21# a_66_297# VPB sky130_fd_pr__pfet_01v8_hvt ad=0.26 pd=2.52 as=0.135 ps=1.27 w=1 l=0.15
.ends
