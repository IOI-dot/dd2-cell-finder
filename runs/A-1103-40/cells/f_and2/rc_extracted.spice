* NGSPICE file created from f_and2.ext - technology: sky130A

.subckt f_and2 A B VGND VNB VPB VPWR Y
X0 a_63_47.t1 A.t1 VPWR.t1 VPB.t1 sky130_fd_pr__pfet_01v8_hvt ad=0.175 pd=1.35 as=0.26 ps=2.52 w=1 l=0.15 sa=0.26 sb=1.26
X1 VGND.t0 B.t0 a_145_47.t1 VNB.t2 sky130_fd_pr__nfet_01v8 ad=0.11375 pd=1 as=0.11375 ps=1 w=0.65 l=0.15 sa=0.76 sb=0.76
X2 Y.t0 a_63_47.t4 VPWR.t0 VPB.t0 sky130_fd_pr__pfet_01v8_hvt ad=0.26 pd=2.52 as=0.175 ps=1.35 w=1 l=0.15 sa=1.26 sb=0.26
X3 a_145_47.t0 A.t0 a_63_47.t0 VNB.t1 sky130_fd_pr__nfet_01v8 ad=0.11375 pd=1 as=0.169 ps=1.82 w=0.65 l=0.15 sa=0.26 sb=1.26
X4 VPWR.t2 B.t1 a_63_47.t2 VPB.t2 sky130_fd_pr__pfet_01v8_hvt ad=0.175 pd=1.35 as=0.175 ps=1.35 w=1 l=0.15 sa=0.76 sb=0.76
X5 Y.t1 a_63_47.t3 VGND.t1 VNB.t0 sky130_fd_pr__nfet_01v8 ad=0.169 pd=1.82 as=0.11375 ps=1 w=0.65 l=0.15 sa=1.26 sb=0.26
R0 VGND VGND.n0 219.928
R1 VGND.n0 VGND.t0 32.3082
R2 VGND.n0 VGND.t1 32.3082
R3 Y Y.n0 6.4005
R4 Y Y.n1 6.4005
R5 Y.n1 Y.n0 157.365
R6 Y.n1 Y.t0 853.981
R7 Y.n0 Y.t1 268.077
R8 VPWR VPWR.n0 0.463182
R9 VPWR.n0 VPWR.n1 619.465
R10 VPWR.n1 VPWR.t2 34.4755
R11 VPWR.n1 VPWR.t0 34.4755
R12 VPWR.n0 VPWR.t1 269.943
R13 B B.n0 158.4
R14 B.n0 B.t0 169.237
R15 B.n0 B.t1 241.536
R16 A A.n0 158.4
R17 A.n0 A.t0 169.237
R18 A.n0 A.t1 241.536
R19 VPB VPB.t1 298.911
R20 VPB.t1 VPB.t2 295.95
R21 VPB.t2 VPB.t0 295.95
R22 VNB VNB.t1 1438.19
R23 VNB.t1 VNB.t2 1423.95
R24 VNB.t2 VNB.t0 1423.95
R25 a_145_47.t0 a_145_47.t1 64.6159
R26 a_63_47.t1 a_63_47.n0 34.4755
R27 a_63_47.n0 a_63_47.t2 34.4755
R28 a_63_47.n0 a_63_47.n2 280.176
R29 a_63_47.n2 a_63_47.n1 152
R30 a_63_47.n2 a_63_47.t0 229.351
R31 a_63_47.n1 a_63_47.t3 169.237
R32 a_63_47.n1 a_63_47.t4 241.536
C0 VPB A 0.03484f
C1 VGND A 0.01326f
C2 Y A 0
C3 VPB Y 0.01926f
C4 VGND VPB 0.01088f
C5 VGND Y 0.04307f
C6 B A 0.03085f
C7 B VPB 0.02894f
C8 B Y 0.00102f
C9 B VGND 0.0163f
C10 VPWR A 0.03242f
C11 VPB VPWR 0.08707f
C12 Y VPWR 0.04338f
C13 VGND VPWR 0.02708f
C14 B VPWR 0.01712f
C15 VGND VNB 0.42883f
C16 Y VNB 0f
C17 VPWR VNB 0.16525f
C18 B VNB 0.01897f
C19 A VNB 0.05869f
C20 VPB VNB 0.39005f
C21 a_63_47.t1 VNB 0.0463f
C22 a_63_47.n0 VNB 0.07349f
C23 a_63_47.n1 VNB 0.03891f
C24 a_63_47.n2 VNB 0.17888f
C25 a_63_47.t0 VNB 0.084f
C26 a_63_47.t2 VNB 0.05185f
C27 a_145_47.t0 VNB 0.02954f
C28 a_145_47.t1 VNB 0.03354f
C29 VPB.t0 VNB 0.09134f
C30 VPB.t1 VNB 0.04211f
C31 VPB.t2 VNB 0.0419f
C32 A.n0 VNB 0.04857f
C33 B.n0 VNB 0.05977f
C34 VPWR.n0 VNB 0.09937f
C35 VPWR.t1 VNB 0.06351f
C36 VPWR.t2 VNB 0.04208f
C37 VPWR.t0 VNB 0.03194f
C38 VPWR.n1 VNB 0.02577f
C39 Y.t1 VNB 0.04438f
C40 Y.n0 VNB 0.04411f
C41 Y.t0 VNB 0.06664f
C42 Y.n1 VNB 0.04562f
C43 VGND.t0 VNB 0.02799f
C44 VGND.t1 VNB 0.02066f
C45 VGND.n0 VNB 0.01509f
.ends
