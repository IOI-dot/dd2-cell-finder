* NGSPICE file created from a_nand3_r1.ext - technology: sky130A

.subckt a_nand3_r1 A B C VGND VNB VPB VPWR Y
X0 Y.t0 C.t1 VPWR.t0 VPB.t2 sky130_fd_pr__pfet_01v8_hvt ad=0.26 pd=2.52 as=0.135 ps=1.27 w=1 l=0.15 sa=1.16 sb=0.26
X1 VPWR.t2 B.t1 Y.t2 VPB.t1 sky130_fd_pr__pfet_01v8_hvt ad=0.135 pd=1.27 as=0.165 ps=1.33 w=1 l=0.15 sa=0.74 sb=0.68
X2 a_205_47.t0 B.t0 a_109_47.t1 VNB.t1 sky130_fd_pr__nfet_01v8 ad=0.08775 pd=0.92 as=0.10725 ps=0.98 w=0.65 l=0.15 sa=0.74 sb=0.68
X3 VGND.t0 C.t0 a_205_47.t1 VNB.t2 sky130_fd_pr__nfet_01v8 ad=0.169 pd=1.82 as=0.08775 ps=0.92 w=0.65 l=0.15 sa=1.16 sb=0.26
X4 Y.t1 A.t1 VPWR.t1 VPB.t0 sky130_fd_pr__pfet_01v8_hvt ad=0.165 pd=1.33 as=0.26 ps=2.52 w=1 l=0.15 sa=0.26 sb=1.16
X5 a_109_47.t0 A.t0 Y.t3 VNB.t0 sky130_fd_pr__nfet_01v8 ad=0.10725 pd=0.98 as=0.169 ps=1.82 w=0.65 l=0.15 sa=0.26 sb=1.16
R0 VGND VGND.t0 299.582
R1 Y.n3 Y.t3 135.022
R2 Y Y.n3 3.29747
R3 Y.n1 Y.n3 150.501
R4 Y.n1 Y.t0 222.542
R5 Y.n0 Y.n2 193.627
R6 Y.n0 Y.n1 28.2949
R7 Y Y.n0 7.52007
R8 Y.n2 Y.t1 32.5055
R9 Y.n2 Y.t2 32.5055
R10 VPWR VPWR.n0 0.358312
R11 VPWR.n0 VPWR.n1 614.097
R12 VPWR.n1 VPWR.t2 26.5955
R13 VPWR.n1 VPWR.t0 26.5955
R14 VPWR.n0 VPWR.t1 266.113
R15 C C.n0 155.298
R16 C.n0 C.t0 158.064
R17 C.n0 C.t1 230.363
R18 B B.n0 155.298
R19 B.n0 B.t0 169.237
R20 B.n0 B.t1 241.536
R21 A A.n0 155.298
R22 A.n0 A.t0 169.237
R23 A.n0 A.t1 241.536
R24 VPB VPB.t0 192.369
R25 VPB.t0 VPB.t1 284.113
R26 VPB.t1 VPB.t2 248.599
R27 VNB VNB.t0 925.567
R28 VNB.t0 VNB.t1 1366.99
R29 VNB.t1 VNB.t2 1196.12
R30 a_205_47.t0 a_205_47.t1 49.8467
R31 a_109_47.t0 a_109_47.t1 60.9236
C0 A Y 0.02934f
C1 B VPB 0.0261f
C2 VGND VPB 0.00584f
C3 C B 0.02548f
C4 VPWR B 0.01688f
C5 VGND C 0.02404f
C6 VPWR VGND 0.02109f
C7 B Y 0.06349f
C8 VGND Y 0.10255f
C9 A B 0.03636f
C10 A VGND 0.00983f
C11 C VPB 0.03716f
C12 VPWR VPB 0.0588f
C13 VGND B 0.01021f
C14 Y VPB 0.01915f
C15 VPWR C 0.01462f
C16 VPWR Y 0.15312f
C17 C Y 0.06021f
C18 A VPB 0.0303f
C19 A VPWR 0.02993f
C20 VGND VNB 0.38838f
C21 Y VNB 0f
C22 VPWR VNB 0.12201f
C23 C VNB 0.06462f
C24 B VNB 0.01916f
C25 A VNB 0.06825f
C26 VPB VNB 0.32972f
C27 a_109_47.t0 VNB 0.02675f
C28 a_109_47.t1 VNB 0.03184f
C29 a_205_47.t0 VNB 0.02786f
C30 a_205_47.t1 VNB 0.02358f
C31 VPB.t0 VNB 0.03215f
C32 VPB.t1 VNB 0.03595f
C33 VPB.t2 VNB 0.0695f
C34 A.n0 VNB 0.04422f
C35 B.n0 VNB 0.05842f
C36 C.n0 VNB 0.06497f
C37 VPWR.n0 VNB 0.091f
C38 VPWR.t1 VNB 0.06237f
C39 VPWR.t2 VNB 0.03901f
C40 VPWR.t0 VNB 0.03313f
C41 VPWR.n1 VNB 0.02062f
C42 Y.n0 VNB 0.04166f
C43 Y.n1 VNB 0.14001f
C44 Y.n2 VNB 0.03807f
C45 Y.t1 VNB 0.04083f
C46 Y.t2 VNB 0.04788f
C47 Y.t0 VNB 0.0779f
C48 Y.n3 VNB 0.0842f
C49 Y.t3 VNB 0.04718f
C50 VGND.t0 VNB 0.03681f
.ends
