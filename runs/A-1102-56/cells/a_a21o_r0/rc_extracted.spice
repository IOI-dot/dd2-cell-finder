* NGSPICE file created from a_a21o_r0.ext - technology: sky130A

.subckt a_a21o_r0 A B C VGND VNB VPB VPWR Y
X0 VGND C a_243_47# VNB sky130_fd_pr__nfet_01v8 ad=0.25675 pd=1.44 as=0.11375 ps=1 w=0.65 l=0.15 sa=1.26 sb=1.2
X1 a_243_47# C a_61_297# VPB sky130_fd_pr__pfet_01v8_hvt ad=0.26 pd=2.52 as=0.175 ps=1.35 w=1 l=0.15 sa=1.26 sb=0.26
X2 a_243_47# A a_143_47# VNB sky130_fd_pr__nfet_01v8 ad=0.11375 pd=1 as=0.11375 ps=1 w=0.65 l=0.15 sa=0.76 sb=1.7
X3 a_61_297# A VPWR VPB sky130_fd_pr__pfet_01v8_hvt ad=0.175 pd=1.35 as=0.175 ps=1.35 w=1 l=0.15 sa=0.76 sb=0.76
X4 Y a_243_47# VPWR VPB sky130_fd_pr__pfet_01v8_hvt ad=0.26 pd=2.52 as=0.26 ps=2.52 w=1 l=0.15 sa=0.26 sb=0.26
X5 Y a_243_47# VGND VNB sky130_fd_pr__nfet_01v8 ad=0.169 pd=1.82 as=0.25675 ps=1.44 w=0.65 l=0.15 sa=2.2 sb=0.26
X6 a_143_47# B VGND VNB sky130_fd_pr__nfet_01v8 ad=0.11375 pd=1 as=0.169 ps=1.82 w=0.65 l=0.15 sa=0.26 sb=2.2
X7 VPWR B a_61_297# VPB sky130_fd_pr__pfet_01v8_hvt ad=0.175 pd=1.35 as=0.26 ps=2.52 w=1 l=0.15 sa=0.26 sb=1.26
C0 VPB VPWR 0.10222f
C1 VPB C 0.03447f
C2 VPWR C 0.01741f
C3 a_143_47# B 0
C4 a_143_47# A 0.00229f
C5 B a_61_297# 0.02805f
C6 A a_61_297# 0.02555f
C7 Y VGND 0.04263f
C8 a_143_47# VPWR 0.00158f
C9 a_61_297# VPWR 0.11508f
C10 VPB a_61_297# 0.016f
C11 a_61_297# C 0.01365f
C12 a_243_47# VGND 0.113f
C13 Y a_243_47# 0.0679f
C14 B VGND 0.03013f
C15 A VGND 0.02137f
C16 a_143_47# a_61_297# 0.00118f
C17 VPB VGND 0.01407f
C18 VPWR VGND 0.03774f
C19 C VGND 0.01608f
C20 VPB Y 0.01973f
C21 Y VPWR 0.04374f
C22 B a_243_47# 0.00292f
C23 Y C 0
C24 A a_243_47# 0.00714f
C25 A B 0.03085f
C26 a_143_47# VGND 0.01579f
C27 VPWR a_243_47# 0.07997f
C28 VPB a_243_47# 0.0627f
C29 a_61_297# VGND 0.00798f
C30 C a_243_47# 0.04882f
C31 B VPB 0.03291f
C32 B VPWR 0.01515f
C33 A VPWR 0.01766f
C34 A VPB 0.02921f
C35 A C 0.03085f
C36 a_143_47# a_243_47# 0.00554f
C37 a_61_297# a_243_47# 0.03261f
C38 VGND VNB 0.50467f
C39 Y VNB 0.17907f
C40 VPWR VNB 0.41374f
C41 VPB VNB 0.69336f
C42 a_143_47# VNB 0.07345f
C43 a_61_297# VNB 0.03155f
.ends
